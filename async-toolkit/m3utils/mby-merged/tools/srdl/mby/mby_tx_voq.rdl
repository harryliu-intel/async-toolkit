
`include "mby_port_cfg.rdl"


/////////////////////////////////////////////////////////////////////////////
// TX_VOQ_PORT_CFG

reg tx_voq_port_cfg_r {
  shared;
  HandCoded = true;
  name = "Tx VOQ Port Configuration.";
  desc = "
      Port configuration for the Tx VOQ.
      The head buffer allocation and scheduler time-slicing are derived from this configuration.
      The port index is N*4 + M. The port configuration values are:

      [list]
      [*] 0 = Disable this port.
      [*] 1 = This port is 100G, 50G, or 25G.
      [*] 2 = This port is 200G. Only port N.0 or N.2 can be 200G, and the next port must be disabled.
      [*] 3 = This port is 400G. Only port N.0 can be 400G, and the next 3 ports must be disabled.
      [/list]
     ";
  regwidth = 64;
  accesswidth = 64;

  field {
    AccessType = "RW";
    desc = "Port configurations, the configuration for port i runs from bit 2*i to bit 2*i+1";
    ValRandomize = true;
  }  PORT[32];

//<% for (my $i = 0; $i < 16; $i++) { %>
//  field {
//    encode = mby_port_cfg_enum;
//    AccessType = "RW";
//    desc = "Port <%=$i%> configuration";
//    ValRandomize = true;
//  } PORT_<%=$i%> [<%=$i*2+1%>:<%=$i*2%>] = 2'h0;
//<% } %>

};


/////////////////////////////////////////////////////////////////////////////
// Tx VOQ addrmap

addrmap mby_tx_voq_map {
  name = "mby_tx_voq";
  desc = "Tx VOQ Register Set";
  Space = "MSG";
  Opcode = "MEM-SB";
  No_IOSF_Primary = true;
  addressing = fullalign;

  tx_voq_port_cfg_r TX_VOQ_PORT_CFG;
};
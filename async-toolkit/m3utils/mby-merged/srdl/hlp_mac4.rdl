//------------------------------------------------------------------------------
//
//  INTEL CONFIDENTIAL
//
//  Copyright 2006 - 2015 Intel Corporation All Rights Reserved.
//
//  The source code contained or described herein and all documents related 
//  to the source code ("Material") are owned by Intel Corporation or its
//  suppliers or licensors. Title to the Material remains with Intel
//  Corporation or its suppliers and licensors. The Material contains trade
//  secrets and proprietary and confidential information of Intel or its
//  suppliers and licensors. The Material is protected by worldwide copyright
//  and trade secret laws and treaty provisions. No part of the Material may
//  be used, copied, reproduced, modified, published, uploaded, posted, 
//  transmitted, distributed, or disclosed in any way without Intel's prior
//  express written permission.
//
//  No license under any patent, copyright, trade secret or other intellectual
//  property right is granted to or conferred upon you by disclosure or
//  delivery of the Materials, either expressly, by implication, inducement,
//  estoppel or otherwise. Any license under such intellectual property rights
//  must be express and approved by Intel in writing.
//
//------------------------------------------------------------------------------

`include "hlp_udp.rdl"
<% use security; %>
<% my %Security_Props = security::GetSecurityInfo(); %>
`include "hlp_mem_gen.rdl"
<% use security; %>
<% my %Security_Props = security::GetSecurityInfo(); %>

reg mac4_scratch_r {
  Security_PolicyGroup     = <%=$Security_Props{'HLP_PG1'}%>;
  Security_ReadAccess_Str  = <%=$Security_Props{'HLP_PG1_RAC_AGENTS'}%>;
  Security_WriteAccess_Str = <%=$Security_Props{'HLP_PG1_WAC_AGENTS'}%>;
  shared;
  HandCoded = true;
  name = "MAC4 Scratchpad Register";
  desc = "Scratchpad register for diagnostic purposes.";
  regwidth = 64;
  accesswidth = 64;
  field {
    AccessType = "RW";
    desc = "Scratchpad";
    ValRandomize = true;
  } SCRATCH[63:0] = 64'h0;
}; // mac4_scratch_r

reg mac4_ip_r {
  Security_PolicyGroup     = <%=$Security_Props{'HLP_PG1'}%>;
  Security_ReadAccess_Str  = <%=$Security_Props{'HLP_PG1_RAC_AGENTS'}%>;
  Security_WriteAccess_Str = <%=$Security_Props{'HLP_PG1_WAC_AGENTS'}%>;
  shared;
  HandCoded = true;
  name = "MAC4 Interrupt Pending Register";
  desc = "Interrupt Pending Register for MAC4";
  regwidth = 64;
  accesswidth = 64;
  field {
    AccessType = "RW/1C/V";
    desc = "Shell Control Memory Error Interrupt";
    ValRandomize = true;
  } SHELL_CTRL_ERR[0:0] = 1'h0;
}; // mac4_ip_r

reg mac4_im_r {
  Security_PolicyGroup     = <%=$Security_Props{'HLP_PG1'}%>;
  Security_ReadAccess_Str  = <%=$Security_Props{'HLP_PG1_RAC_AGENTS'}%>;
  Security_WriteAccess_Str = <%=$Security_Props{'HLP_PG1_WAC_AGENTS'}%>;
  shared;
  HandCoded = true;
  name = "MAC4 Interrupt Mask Register";
  desc = "Interrupt Mask Register for MAC4";
  regwidth = 64;
  accesswidth = 64;
  field {
    AccessType = "RW";
    desc = "Shell Control Memory Error Interrupt Mask";
    ValRandomize = true;
  } SHELL_CTRL_ERR[0:0] = 1'h1;
}; // mac4_im_r

addrmap hlp_MAC4_map {
  name = "hlp_MAC4";
  desc = "MAC4 Registers";
  ArrayedMaps = 8;
  AddressBits = 10;
  ResetDomains = "PORTS,MGMT";
  addressing = fullalign;
  Space = "MSG";
  Opcode = "MEM-SB";
  No_IOSF_Primary=true;


  mac4_scratch_r         MAC4_SCRATCH                       @0x000;
  mac4_ip_r              MAC4_IP                            @0x008;
  mac4_im_r              MAC4_IM                            @0x010;
  
  // Note: the MAC4_SHELL_CTL regs start at 0x018 within this address space
  //       so adding any more common MAC4 regs will require them to move
  
};

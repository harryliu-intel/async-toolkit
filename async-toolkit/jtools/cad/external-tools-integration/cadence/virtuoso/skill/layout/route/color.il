; Copyright (c) 2025 Intel Corporation.  All rights reserved.  See the file COPYRIGHT for more information.
; SPDX-License-Identifier: Apache-2.0

; create a FQCN_reverse_color_m0 overlay cell to reverse m0 coloring
(defun ReverseColorM0 (@key (CV (geGetEditCellView)))
  (let (inMapping outMapping cellName dstCV)
    cellName = (strcat CV->cellName "_reverseColorM0")
    inMapping = '(("m0draw"  ("m0"  "drawing"))
                  ("mc0comp" ("mc0" "complement"))
                  ("mc0draw" ("mc0" "drawing")))
    outMapping = '(("a" ("mc0" "complement"))
                   ("b" ("m0" "backBone")))
    dstCV = (dbOpenCellViewByType CV->libName cellName "layout" "maskLayout" "w")
    (ICVLayerProcessorSimple CV dstCV "reverseColorM0" inMapping outMapping)
    )
  )

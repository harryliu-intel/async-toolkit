; Copyright 2003 Fulcrum Microsystems.  All rights reserved.
; $Id$
; $DateTime$
; $Author$

; choose automatically which type of abstract to make
(defun MakeAbstract (@key (CV (geGetEditCellView))
                          (cutaroundpins t)
                          (topMetal nil))
  (if (IsLeafCell CV->cellName)
    (MakeLeafAbstract ?CV CV)
    (MakeSimpleAbstract ?CV CV ?cutaroundpins cutaroundpins ?topMetal topMetal)
    )
  )

; compatibility wrapper for UI menu
(defun MakeMidAbstract (@key (CV (geGetEditCellView)))
  (MakeSimpleAbstract ?CV CV)
  )

;;;;;;;;;;;;;;;;;;;;;;;;;;;;; MakeSimpleAbstract ;;;;;;;;;;;;;;;;;;;;;;;;;;;;;;;

(defun MakeSimpleAbstract (@key (CV (geGetEditCellView))
                                (cutaroundpins t)
                                (topMetal nil)
                                (convertpinvias t)
                                )
 (let (abstractCV name net fig term pinlayer map inLayerMap outLayerMap inst
       allpinfigs pinsonlayer allblockages viashape)

  ; set topMetal
  (unless topMetal topMetal = (dbGetPropByName CV "topMetal")->value)
  (unless topMetal (LoadWires ?CV CV) topMetal = bundled_top_layer)

  ; create view
  abstractCV=(dbOpenCellViewByType CV->libName CV->cellName "abstract" "maskLayout" "w")
  (when !abstractCV
    (printf "Couldn't edit abstract view for %s\n" CV->cellName)
    (error "Cellview not writable.\n")
  )
  (printf "Generating abstract of %s at %s\n" CV->cellName (getCurrentTime))
  (foreach shape abstractCV->shapes
    (when shape (dbDeleteObject shape) )
    )

  ; create prBoundary
  prb = (dbCreatePRBoundary abstractCV (GetPrboundPoints CV))
  (dbCreatePolygon abstractCV BoundaryLPP (GetPrboundPoints CV))

  ; instantiate layout view so we can flatten its shapes
  inst = (dbCreateInst abstractCV CV "inst" 0:0 "R0")

  ; invert keepout (use blockage layer to avoid polygons with too many points)
  (for m 0 topMetal (AbstractInvertKeepout (list Metal[m] "blockage") CV abstractCV))

  ; flood via keepout (use blockage layer to avoid polygons with too many points)
  ; keep vias within a lego spacing of the prBoundary just to be safe!
  (for m 0 topMetal-2 (AbstractInvertKeepout (list Via[m] "blockage") CV abstractCV ?space 0:0))

  ; create keepout for all existing vias and metal
  (for m 0 TopMetal-1
       name = Via[m]
       map = (list name)
       (foreach purpose (list "drawing" "gnd" "vdd" "fill")
                map = (append map (list (list Via[m] purpose)))
                )
       inLayerMap = (cons map inLayerMap)
       outLayerMap = (cons (list name (list Via[m] KeepoutPurpose)) outLayerMap)
       map = (list (sprintf nil "flood_%s" Via[m]) (list Via[m] "blockage"))
       inLayerMap = (cons map inLayerMap)
       )
  (for m 0 TopMetal
       name = Metal[m]
       map = (list name)
       (foreach purpose (list "drawing" "gnd" "vdd" "fill")
                map = (append map (list (list Metal[m] purpose)))
                (when m==0 || m>=2 && m<=5 ; complement layers too
                      map = (append map (list (list (sprintf nil "mc%d" m) purpose)))
                      )
                )
       inLayerMap = (cons map inLayerMap)
       outLayerMap = (cons (list name (list Metal[m] KeepoutPurpose)) outLayerMap)
       map = (list (sprintf nil "flood_%s" Metal[m]) (list Metal[m] "blockage"))
       inLayerMap = (cons map inLayerMap)
       )

  (ICVLayerProcessorSimple abstractCV abstractCV "MakeAbstract" inLayerMap outLayerMap)

  ; convert blockages to keepout (avoid polygons with too many points)
  (foreach shape abstractCV->shapes
           (when shape->purpose=="blockage"
                 shape->lpp = (list (car shape->lpp) "keepout")
                 )
           )

  ; delete the inst
  (dbDeleteObject inst)

  ; copy pins to abstract
  pinlayer = (makeTable "pinlayer" nil)
  (foreach shape CV->shapes
    (when shape->pin
      name=shape->net->name
      net=(dbFindNetByName abstractCV name)
      (unless net net=(dbCreateNet abstractCV name))
      term=(dbFindTermByName abstractCV name)
      (unless term term=(dbCreateTerm net name shape->pin->term->direction))
      fig=(dbCopyFig shape abstractCV)
      fig->lpp = (list (car fig->lpp) "drawing")
      (dbCreatePin net fig)
      allpinfigs = (cons fig allpinfigs)
      (for m 0 TopMetal
           (when shape->layerName==Metal[m] pinlayer[m]=t)
           )
      )
    )
  (DeleteLabels ?CV abstractCV)

  ; chop keepouts around pins
  (when cutaroundpins
    (for m 0 TopMetal
         (when pinlayer[m]
           (AbstractCutAroundPins abstractCV MetalDrawing[m] MetalKeepout[m])
           )
         )
    )

  ; for pins, convert the via- or via+ into a pin with the same net
  ; try to filter out the big floodfilled blockage
  (when convertpinvias
    (for m 0 TopMetal
         (when pinlayer[m]
           pinsonlayer = (setof pin allpinfigs (car pin->lpp)==Metal[m])
           (foreach pin pinsonlayer
             allblockages = (FindBlockageOverlaps abstractCV pin->bBox Via[m-1])
             (foreach via allblockages
               viashape = (car via)
               (when (GetFigArea viashape) < DefaultWiringPitch
                 (AttachViaToPin pin via)
                 )
               )
             allblockages = (FindBlockageOverlaps abstractCV pin->bBox Via[m])
             (foreach via allblockages
               viashape = (car via)
               (when (GetFigArea viashape) < DefaultWiringPitch
                 (AttachViaToPin pin via)
                 )
               )
             )
           )
         )
    )

    ; make all remaining vias a member of NULL net, per Georgois's request
    nullnet = (dbCreateNet abstractCV "NULL")
    (for m 0 TopMetal
      (foreach viashape abstractCV->shapes
        (when (car viashape->lpp)==Via[m]
          (when !viashape->net
            (dbCreatePin nullnet viashape)
            )
          )
        )
      )

  ; add M1 blockage on edges
  (BlockEdgeM1 ?CV abstractCV)

  ; save and exit
  (CopyKeepoutToBlockage abstractCV)
  (SetLefProperties abstractCV CV)
  (dbSave abstractCV)
  abstractCV
  )
 )

;;;;;;;;;;;;;;;;;;;;;;;;;;;;; MakeLeafAbstract ;;;;;;;;;;;;;;;;;;;;;;;;;;;;;;;

(defun MakeLeafAbstract (@key (CV (geGetEditCellView))
                              (floodfillM2Keepout nil)
                              (floodfillM1Keepout nil)
                              (floodfillM0Keepout nil)
                              (extendM2Keepout nil)
                              (extendM1Keepout nil)
                              (extendM0Keepout nil)
                              (convertpinvias t)
                              )
  (let (abstractCV name net fig term pin prb dd_CV layer purpose map inLayerMap outLayerMap
         allpinfigs pinsonlayer allblockages viashape m nullnet hasM2fill
         )

    ; sanity check
    (when CV->viewName=="abstract"
          (error "Can't call MakeAbstract on abstract view of %s\n" CV->cellName)
          )

    ; check for prBoundary first
    prb = (GetPrbound CV)
    (unless prb (error "No prBoundary object in %s\n" CV->cellName))

    ; check if it has m2 fill shapes
    hasM2fill = (setof x CV->shapes x->lpp==(list "m2" "fill"))!=nil

    ; create empty abstract view
    (printf "Generating abstract of %s at %s\n" CV->cellName (getCurrentTime))
    abstractCV=(dbOpenCellViewByType CV->libName CV->cellName "abstract" "maskLayout" "w")
    (when !abstractCV (error "Couldn't edit abstract view for %s\n" CV->cellName))

    ; flatten pcells and vias to abstract_temp view
    CV=(betterCopyCellView CV CV->libName CV->cellName "abstract_temp" nil nil t)
    (when !CV (error "Couldn't edit abstract_temp view for %s\n" CV->cellName))
    (foreach inst CV->instances (dbFlattenInst inst 32 t))
    (foreach inst CV->vias      (dbFlattenInst inst 32 t))
    (dbSave CV)

    ; create prBoundary
    (dbCreatePRBoundary abstractCV (GetPrboundPoints CV))
    (dbCreatePolygon abstractCV BoundaryLPP (GetPrboundPoints CV))

    ; flood fill
    (when floodfillM0Keepout (AbstractInvertKeepout MetalKeepout[0] CV abstractCV) )
    (when floodfillM1Keepout (AbstractInvertKeepout MetalKeepout[1] CV abstractCV) )
    (when floodfillM2Keepout (AbstractInvertKeepout MetalKeepout[2] CV abstractCV) )

    ; extend keepout to left and right sides of cell
    (when !floodfillM2Keepout && extendM2Keepout (AbstractExtendHorizontal CV 2 prb->bBox))
    (when !floodfillM1Keepout && extendM1Keepout (AbstractExtendVertical   CV 1 prb->bBox))
    (when !floodfillM0Keepout && extendM0Keepout (AbstractExtendHorizontal CV 0 prb->bBox))

    ; copy pins on metal layers
    (foreach shape CV->shapes
             (when shape->pin && (isMetal (car shape->lpp))
               name=shape->net->name
               net=(dbFindNetByName abstractCV name)
               (unless net net=(dbCreateNet abstractCV name))
               term=(dbFindTermByName abstractCV name)
               (unless term term=(dbCreateTerm net name shape->pin->term->direction))
               pin=(car term->pins)
               (unless pin pin=(dbCreatePin net nil))
               fig=(dbCopyFig shape abstractCV)
               fig->lpp = (list (car fig->lpp) "drawing")
               (dbAddFigToPin pin fig) ; strongly connected figures
               allpinfigs = (cons fig allpinfigs)
               )
             )
    (DeleteLabels ?CV abstractCV)

    ; chop flooded/extended keepout near pins
    (for m 0 4 (AbstractCutAroundPins abstractCV MetalDrawing[m] MetalKeepout[m]))

    ; create keepout for vias and metal
    (for m 0 3
         name = Via[m]
         map = (list name)
         (foreach purpose (list "drawing" "gnd" "vdd" "fill")
                  map = (append map (list (list Via[m] purpose)))
                  )
         inLayerMap = (cons map inLayerMap)
         outLayerMap = (cons (list name (list Via[m] KeepoutPurpose)) outLayerMap)
         )
    (for m 0 4
         name = Metal[m]
         map = (list name)
         (foreach purpose (list "drawing" "gnd" "vdd" "fill")
                  map = (append map (list (list Metal[m] purpose)))
                  (when m==0 || m==2 ; complement layers too
                        map = (append map (list (list (sprintf nil "mc%d" m) purpose)))
                        )
                  )
         inLayerMap = (cons map inLayerMap)
         outLayerMap = (cons (list name (list Metal[m] KeepoutPurpose)) outLayerMap)
         )
    (ICVLayerProcessorSimple CV abstractCV "mergeShape" inLayerMap outLayerMap)

    ; chop keepout overlapping pins
    (for m 0 4 (AbstractCutAroundPins abstractCV MetalDrawing[m] MetalKeepout[m] ?cutout 0:0))

    ; add M1:keepout on edges if M2:fill is used in cell
    (when TechLibName=="731" && hasM2fill (BlockEdgeM1 ?CV abstractCV))

    ; create final boundary shapes and blockage objects
    ; (leMergeShapes abstractCV->shapes)
    (CopyKeepoutToBlockage abstractCV)
    (Colorize ?CV abstractCV ?doBlockages t)

  ; for pins, convert the via- or via+ into a pin with the same net
  ; try to filter out the big floodfilled blockage
  (when convertpinvias
    m = 0
           pinsonlayer = (setof pin allpinfigs (car pin->lpp)==Metal[m])
           (foreach pin pinsonlayer
             allblockages = (FindBlockageOverlaps abstractCV pin->bBox Via[m])
             (foreach via allblockages
               viashape = (car via)
               (when (GetFigArea viashape) < DefaultWiringPitch
                 (AttachViaToPin pin via)
                 )
               )
             )
    (for m 1 2
           pinsonlayer = (setof pin allpinfigs (car pin->lpp)==Metal[m])
           (foreach pin pinsonlayer
             allblockages = (FindBlockageOverlaps abstractCV pin->bBox Via[m-1])
             (foreach via allblockages
               viashape = (car via)
               (when (GetFigArea viashape) < DefaultWiringPitch
                 (AttachViaToPin pin via)
                 )
               )
             allblockages = (FindBlockageOverlaps abstractCV pin->bBox Via[m])
             (foreach via allblockages
               viashape = (car via)
               (when (GetFigArea viashape) < DefaultWiringPitch
                 (AttachViaToPin pin via)
                 )
               )
             )
           )
    )

    ; make all remaining vias a member of NULL net, per Georgois's request
    nullnet = (dbFindNetByName abstractCV "NULL")
    (unless nullnet nullnet = (dbCreateNet abstractCV "NULL"))
    (for m 0 3
      (foreach viashape abstractCV->shapes
        (when (car viashape->lpp)==Via[m]
          (when !viashape->net
            (dbCreatePin nullnet viashape)
            )
          )
        )
      )

    ; save and exit
    (SetLefProperties abstractCV CV ?leaf t)
    (dbSave abstractCV)
    dd_CV = (ddGetObj abstractCV->libName abstractCV->cellName "abstract_temp")
    (when dd_CV (ddDeleteObj dd_CV))
    abstractCV
    )
  )

;;;;;;;;;;;;;;;;;;;;;;;;;;;;;;;;;;; Utilities ;;;;;;;;;;;;;;;;;;;;;;;;;;;;;;;;;;;;;;

; copy MetalKeepout and ViaKeepout to blockage objects
(defun CopyKeepoutToBlockage (cv)
  (let (shapes)
    (foreach shape cv->shapes
       (when shape->purpose=="keepout"
             shapes = (dbLayerTile cv shape->lpp (list shape)) ; convert to rectangles
             (foreach shape shapes
                      (dbCreateLayerBlockage cv shape->layerName "routing"
                                             (RectGetPolygonPoints shape->bBox))
                      (dbCreateLayerBlockage cv shape->layerName "fill"
                                             (RectGetPolygonPoints shape->bBox))
                      (dbDeleteObject shape)
                      )
             )
       )
    )
  t
  )

; set properties for LEF export
(defun SetLefProperties (CV srcCV @key (powergrid nil) (leaf nil))
  (let (net v)
    (cond (powergrid CV->cellType="cover")
          (leaf      CV->cellType="core")
          (t         CV->cellType="block")
          )
    (dbSetCellViewSymmetry CV "any") ; SYMMETRY X Y R90
    v = (caddr (GetLibHeightVariant ?CV srcCV))
    (cond (v=="1" || v=="2" || v=="3" CV->sitePattern = (list (list "core"   0:0 "R0")))
          (v=="0" || v=="4" || v=="5" CV->sitePattern = (list (list "corev2" 0:0 "R0")))
          (v=="h"                     CV->sitePattern = (list (list "halo"   0:0 "R0")))
          (t                          CV->sitePattern = nil)
          )
    (foreach name PowerNets
             net = (dbFindNetByName CV name)
             (when net net->term->direction="inputOutput" net->sigType = "supply") ; USE POWER
             )
    (foreach name GroundNets
             net = (dbFindNetByName CV name)
             (when net net->term->direction="inputOutput" net->sigType = "ground") ; USE GROUND
             )
    )
  )

; Chop holes in flooded keepout around pins
(defun AbstractCutAroundPins (cv pinlpp keepoutlpp @key (cutout nil))
  (unless cutout cutout = MetalSpace[(car pinlpp)])
  (betterLayerSize cv pinlpp cutout Scratch1LPP)
  (leLayerAndNot cv keepoutlpp Scratch1LPP Scratch2LPP)
  (foreach shape cv->shapes
           (cond (shape->lpp==keepoutlpp  (dbDeleteObject shape))
                 (shape->lpp==Scratch1LPP (dbDeleteObject shape))
                 (shape->lpp==Scratch2LPP shape->lpp=keepoutlpp))
           )
  t
  )

; Floodfill keepout: KEEPOUT = (shrink PRB MetalBoundarySpace) & !(grow KEEPOUT MetalSpace)
(defun AbstractInvertKeepout (lpp cv1 cv2 @key (space nil) (shrink nil))
  (let ()
    (unless space  space= MetalSpace[(car lpp)])
    (unless shrink shrink=FloodfillBoundarySpace[(car lpp)])
    (unless shrink shrink=MetalBoundarySpace[(car lpp)])
    (foreach shape cv1->shapes
             (when shape->lpp==lpp (dbCopyFig shape cv2)->lpp=Scratch1LPP)
             )
    (betterLayerSize cv2 Scratch1LPP space Scratch1LPP)
    (betterLayerSize cv2 BoundaryLPP -(car shrink):-(cadr shrink) Scratch2LPP)
    (leLayerAndNot cv2 Scratch2LPP Scratch1LPP lpp)
    (foreach shape cv2->shapes
             (cond (shape->lpp==Scratch1LPP (dbDeleteObject shape))
                   (shape->lpp==Scratch2LPP (dbDeleteObject shape))
                   )
             )
    )
  t
  )

; Extend keepout to block entire horizontal track
(defun AbstractExtendHorizontal (CV m bbox)
  (let (xy0 xy1 x0 y0 x1 y1 prbSpacing)
    prbSpacing = (car MetalSpace[Metal[m]])/2
    (foreach shape CV->shapes
             (when shape->lpp==MetalDrawing[m] && !shape->pin && shape->objType!="label"
                   xy0=(car  shape->bBox)
                   xy1=(cadr shape->bBox)
                   y0=(cadr xy0)
                   y1=(cadr xy1)
                   x0=(car (car bbox))+prbSpacing
                   x1=(car (cadr bbox))-prbSpacing
                   (dbCreateRect abstractCV MetalKeepout[m] (list x0:y0 x1:y1))
                   )
             )
    )
  t
  )

; Extend keepout to block entire vertical track
(defun AbstractExtendVertical (CV m bbox)
  (let (xy0 xy1 x0 y0 x1 y1 prbSpacing)
    prbSpacing = (cadr MetalSpace[Metal[m]])/2
    (foreach shape CV->shapes
             (when shape->lpp==MetalDrawing[m] && !shape->pin && shape->objType!="label"
                   xy0=(car  shape->bBox)
                   xy1=(cadr shape->bBox)
                   y0=(cadr xy0)
                   y1=(cadr xy1)
                   x0=(car xy0)
                   x1=(car xy1)
                   y0=(cadr (car bbox))+prbSpacing
                   y1=(cadr (cadr bbox))-prbSpacing
                   (dbCreateRect abstractCV MetalKeepout[m] (list x0:y0 x1:y1))
                   )
             )
    )
  t
  )

; find overlaps on "keepout" purpose, return list of polygon/blockage pairs
(defun FindBlockageOverlaps (CV bbox layerName)
  (let (alloverlaps overlaps keepouts keepout blockage)
    alloverlaps = (dbGetOverlaps CV bbox)
    keepouts = (setof overlap alloverlaps (car overlap->lpp)==layerName && (cadr overlap->lpp)=="keepout")
    (foreach keepout keepouts
      blockage = (car (setof blockage CV->blockages blockage->bBox==keepout->bBox))
      ; if this (car) doesn't work right, we'll have to do something more clever to loop through
      ; all overlapping blockages
      overlaps = (cons (list keepout blockage) overlaps)
      )
    overlaps
    )
  )

; for via keepout on pin make it into a pin with same connectivity and delete blockage
; used in conjunction with FindBlockageOverlap above
(defun AttachViaToPin (pinfig blockage)
  (let (viafig block)
    viafig = (car blockage)
    viafig->lpp = (list (car viafig->lpp) "drawing")
    (if pinfig->net then
      (dbCreatePin pinfig->net viafig)
    else
      (printf "No net for figure\n")
      )
    block=(cadr blockage)
    (when block
      (dbDeleteObject block)
      )
    )
  )

;;;;;;;;;;;;;;;;;;;;;;; HACK: implement asymmetric leLayerSize ;;;;;;;;;;;;;;;;;;;;;;;

; like leLayerSize but with asymmetric x:y bloat
(defun betterLayerSize (CV lpp1 xy lpp2)
  (let (points)
    (foreach x (setof s CV->shapes s->lpp==lpp1 && s->objType!="label")
             points = (if x->objType=="polygon" x->points (RectGetPoints x->bBox))
             points = (betterGrowPoints points xy)
             (dbCreatePolygon CV lpp2 points)
             )
    t
    )
  )

; like pcGrowPoints but with asymmetric x:y bloat
; CLEVER: bloat symmetrically by x and y separately then mix coordinates back together
(defun betterGrowPoints (points xy)
  (let (xpoints ypoints newpoints)
    xpoints = (pcGrowPoints points (car  xy))
    ypoints = (pcGrowPoints points (cadr xy))
    (when (length xpoints)!=(length ypoints) (error "betterGrowPoints: (length xpoints)!=(length ypoints)"))
    (for i 0 (length xpoints)-1
         newpoints = (cons (car (nth i xpoints)):(cadr (nth i ypoints)) newpoints)
         )
    newpoints
    )
  )

; Add additional M1 keepout on vertical edges of prBoundary
; to prevent ICC from causing many hard-to-fix routing errors
(defun BlockEdgeM1 (@key (CV (geGetEditCellView)))
  (let (points len w s p0 p1 x0 x1 y0 y1)
    w = (cadr (car node_m1[0]))
    s = (cadr MetalBoundarySpace[Metal[1]])
    points = CV->prBoundary->points
    len = (length points)
    (for i 0 len-1
         p0 = (nth i points)
         p1 = (nth (mod i+1 len) points)
         (when (car p0)==(car p1)
               x0 = (car p0) - w/2
               x1 = (car p0) + w/2
               y0 = (min (cadr p0) (cadr p1)) + s
               y1 = (max (cadr p0) (cadr p1)) - s
               (dbCreateRect CV MetalKeepout[1] (list x0:y0 x1:y1))
               )
         )
    )
  t
  )

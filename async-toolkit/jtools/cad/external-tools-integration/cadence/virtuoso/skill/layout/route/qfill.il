; Run QFILL to add fill and color shapes to a cell
(defun DoFill (@key (CV (geGetEditCellView)) (botLayer "m0") (topLayer "m10")
                    (layers nil) (delete t) (recipe "asic_g1i"))
  (let (TEMP WDIR ExportCV offset all_layers dir cmd CID oasName oasFile qCV fill_layers
             done offset)
    ; pick list of layers to fill
    all_layers = (list "cell"
                       "end_check_grid"
                       "diffcon"
                       "poly" "fti"
                       "vct" "vcg"
                       "m0" "v0"
                       "m1" "v1"
                       "m2" "v2"
                       "m3" "v3"
                       "m4" "v4"
                       "m5" "v5"
                       "m6" "v6"
                       "m7" "v7"
                       "m8" "v8"
                       "m9" "v9"
                       "m10" "v10"
                       "m11" "v11"
                       "m12" "v12"
                       "m13" "v13"
                       "m14" "v14"
                       "m15" "v15")
    (unless (member botLayer all_layers) (error "botLayer not valid"))
    (unless (member topLayer all_layers) (error "topLayer not valid"))
    (when botLayer all_layers = (member botLayer all_layers))
    (unless layers
      done = nil
      (foreach layer all_layers
               (unless done
                 layers = (append layers (list layer))
                 (cond (layer=="v1" layers=(append layers (list "via1_signal_color")))
                       (layer=="v2" layers=(append layers (list "via2_signal_color")))
                       (layer=="v3" layers=(append layers (list "via3_signal_color")))
                       (t fill_layers=t)
                       )
                 done = layer==topLayer
                 )
               )
      )

    ; delete previous qfill shapes
    (when delete (DeleteAutoGen ?CV CV ?propValue "qfill"))

    ; copy to temp view and offset according to alignment properties
    offset = (cadr (GetCellAlignment ?CV CV))
    ExportCV = (betterCopyCellView CV CV->libName CV->cellName "qfill" nil nil t)
    (OffsetEverything offset ?CV ExportCV)
    (dbSave ExportCV)

    ; export OAS
    TEMP = (ConfigFileGetValue TheCDSConfigTable "TEMP")
    WDIR = (strcat TEMP "/oas/" CV->cellName)
    CID = (NameStartRename "cell" "cadence" "gds2")
    oasName = (NameDoRename CID CV->cellName)
    (NameStopRename CID)
    (ExportOAS ?CV ExportCV)

    ; run qfill
    cmd = (sprintf nil "cd %s; qfill run_fill --process %s --recipe qfill_recipe_%s_%s.yaml --layers %s --input_layout %s.oas"
                   WDIR TechLibName TechLibName recipe (buildString layers " ") oasName)
    (printf "%s\n" cmd)
    (shell cmd)

    ; import metal_via_fill
    (when fill_layers
        oasFile = (sprintf nil "%s/qfill_work/qfill_%s_%s_s_%s_run_metal_via_fill/qfill_run_metal_via_fill_output/%s_metal_via_fill.oas" WDIR oasName TechLibName recipe oasName)
        qCV = (ImportOAS oasFile CV->libName (strcat oasName "_metal_via_fill") "qfill")
        (CopyQfillShapes CV qCV offset)
        )

    ; import signal_via_color
    (when (member "via1_signal_color" layers )!=nil ||
          (member "via2_signal_color" layers )!=nil ||
          (member "via3_signal_color" layers )!=nil
          oasFile = (sprintf nil "%s/qfill_work/qfill_%s_%s_s_%s_run_via_coloring/qfill_run_via_coloring_output/%s_signal_via_color.oas" WDIR oasName TechLibName recipe oasName)
          qCV = (ImportOAS oasFile CV->libName (strcat oasName "_signal_via_color") "qfill")
          (CopyQfillShapes CV qCV offset)
          )

    ; Colorize
    (ColorizeByOverlay ?CV CV)
    )
  CV
  )

; Copy shapes from qfill import and set autogen property
(defun CopyQfillShapes (CV qCV offset)
  (let (color)
    (foreach shape qCV->shapes
  	   color = (GetShapeColor shape)
           shape = (dbCopyShape shape CV (list -(car offset):-(cadr offset) "R0"))
	   (SetShapeColor shape color)
           (dbReplaceProp shape "autogen" "string" "qfill")
           )
    qCV
    )
  )

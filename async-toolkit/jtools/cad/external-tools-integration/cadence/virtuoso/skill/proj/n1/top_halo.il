; Add TOP_HALO to a rectangular bbox
(defun AddTopHalo (@key (CV (geGetEditCellView)))
  (let (bbox vCV nCV ncCV scCV bbox x0 y0 x1 y1 xa ya w h)
    vCV = (dbOpenCellViewByType "globals" "globals.TOP_HALO.v" "layout")
    nCV = (dbOpenCellViewByType "globals" "globals.TOP_HALO.n" "layout")
    sCV = (dbOpenCellViewByType "globals" "globals.TOP_HALO.s" "layout")
    ncCV = (dbOpenCellViewByType "globals" "globals.TOP_HALO.nc" "layout")
    scCV = (dbOpenCellViewByType "globals" "globals.TOP_HALO.sc" "layout")
    bbox = CV->prBoundary->bBox
    x0 = (car  (car  bbox))
    y0 = (cadr (car  bbox))
    x1 = (car  (cadr bbox))
    y1 = (cadr (cadr bbox))
    xa = (car gridAlignment["lego"])
    ya = (cadr gridAlignment["lego"])
    w = (round (x1-x0)/xa)
    h = (round (y1-y0)/ya)
    (dbCreateSimpleMosaic CV scCV "sw" x0:y0 "R0" 1 1 ya xa)
    (dbCreateSimpleMosaic CV scCV "se" x1:y0 "MY" 1 1 ya xa)
    (dbCreateSimpleMosaic CV ncCV "nw" x0:y1 "R0" 1 1 ya xa)
    (dbCreateSimpleMosaic CV ncCV "ne" x1:y1 "MY" 1 1 ya xa)
    (dbCreateSimpleMosaic CV sCV   "s" x0+xa:y0 "R0" 1 w-2 ya xa)
    (dbCreateSimpleMosaic CV nCV   "n" x0+xa:y1 "R0" 1 w-2 ya xa)
    (dbCreateSimpleMosaic CV vCV   "w" x0:y0+ya "R0" h-1 1 ya xa)
    (dbCreateSimpleMosaic CV vCV   "e" x1:y0+ya "MY" h-1 1 ya xa)
    CV
    )
  )

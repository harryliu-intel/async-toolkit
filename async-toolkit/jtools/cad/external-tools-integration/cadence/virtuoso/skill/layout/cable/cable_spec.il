; Copyright (c) 2025 Intel Corporation.  All rights reserved.  See the file COPYRIGHT for more information.
; SPDX-License-Identifier: Apache-2.0

;(defvar dense_sbuf_spec strcat( ( ConfigFileGetValue TheCDSConfigTable "VIRTUOSO_HOME" ) "/share/skill/layout/cable/spec_templates/dense_sbuf_spec.cast") )
;(defvar dense_mbuf_spec strcat( ( ConfigFileGetValue TheCDSConfigTable "VIRTUOSO_HOME" ) "/share/skill/layout/cable/spec_templates/dense_mbuf_spec.cast") )
;(defvar dense_rbuf_spec strcat( ( ConfigFileGetValue TheCDSConfigTable "VIRTUOSO_HOME" ) "/share/skill/layout/cable/spec_templates/dense_rbuf_spec.cast") )
;(defvar dense_spec      strcat( ( ConfigFileGetValue TheCDSConfigTable "VIRTUOSO_HOME" ) "/share/skill/layout/cable/spec_templates/dense_spec.cast"     ) )
;
;(defvar nyb_sbuf_spec   strcat( ( ConfigFileGetValue TheCDSConfigTable "VIRTUOSO_HOME" ) "/share/skill/layout/cable/spec_templates/nyb_sbuf_spec.cast") )
;(defvar nyb_mbuf_spec   strcat( ( ConfigFileGetValue TheCDSConfigTable "VIRTUOSO_HOME" ) "/share/skill/layout/cable/spec_templates/nyb_mbuf_spec.cast") )
;(defvar nyb_rbuf_spec   strcat( ( ConfigFileGetValue TheCDSConfigTable "VIRTUOSO_HOME" ) "/share/skill/layout/cable/spec_templates/nyb_rbuf_spec.cast") )
;(defvar nyb_spec        strcat( ( ConfigFileGetValue TheCDSConfigTable "VIRTUOSO_HOME" ) "/share/skill/layout/cable/spec_templates/nyb_spec.cast"     ) )
;
;(defvar ts_sbuf_spec    strcat( ( ConfigFileGetValue TheCDSConfigTable "VIRTUOSO_HOME" ) "/share/skill/layout/cable/spec_templates/ts_sbuf_spec.cast") )
;(defvar ts_mbuf_spec    strcat( ( ConfigFileGetValue TheCDSConfigTable "VIRTUOSO_HOME" ) "/share/skill/layout/cable/spec_templates/ts_mbuf_spec.cast") )
;(defvar ts_rbuf_spec    strcat( ( ConfigFileGetValue TheCDSConfigTable "VIRTUOSO_HOME" ) "/share/skill/layout/cable/spec_templates/ts_rbuf_spec.cast") )
;(defvar ts_spec         strcat( ( ConfigFileGetValue TheCDSConfigTable "VIRTUOSO_HOME" ) "/share/skill/layout/cable/spec_templates/ts_spec.cast"     ) )

;(defvar xbus_adp_spec   strcat( ( ConfigFileGetValue TheCDSConfigTable "VIRTUOSO_HOME" ) "/share/skill/layout/cable/spec_templates/xbus_mbuf_spec.cast") )
;(defvar xbus_mbuf_spec  strcat( ( ConfigFileGetValue TheCDSConfigTable "VIRTUOSO_HOME" ) "/share/skill/layout/cable/spec_templates/xbus_mbuf_spec.cast") )
;(defvar xbus_cable_spec strcat( ( ConfigFileGetValue TheCDSConfigTable "VIRTUOSO_HOME" ) "/share/skill/layout/cable/spec_templates/xbus_spec.cast"     ) )
;(defvar sync_node_spec  strcat( ( ConfigFileGetValue TheCDSConfigTable "VIRTUOSO_HOME" ) "/share/skill/layout/cable/spec_templates/sync_node_spec.cast") )

(defvar dense_sbuf_spec strcat( "/nfs/site/disks/wdisk.83/pankala1/sw/sw/cad/external-tools-integration/cadence/virtuoso/skill/layout/cable/spec_templates/dense_sbuf_spec.cast") )
(defvar dense_mbuf_spec strcat( "/nfs/site/disks/wdisk.83/pankala1/sw/sw/cad/external-tools-integration/cadence/virtuoso/skill/layout/cable/spec_templates/dense_mbuf_spec.cast") )
(defvar dense_rbuf_spec strcat( "/nfs/site/disks/wdisk.83/pankala1/sw/sw/cad/external-tools-integration/cadence/virtuoso/skill/layout/cable/spec_templates/dense_rbuf_spec.cast") )
(defvar dense_spec      strcat( "/nfs/site/disks/wdisk.83/pankala1/sw/sw/cad/external-tools-integration/cadence/virtuoso/skill/layout/cable/spec_templates/dense_spec.cast"     ) )
(defvar nyb_sbuf_spec   strcat( "/nfs/site/disks/wdisk.83/pankala1/sw/sw/cad/external-tools-integration/cadence/virtuoso/skill/layout/cable/spec_templates/nyb_sbuf_spec.cast") )
(defvar nyb_mbuf_spec   strcat( "/nfs/site/disks/wdisk.83/pankala1/sw/sw/cad/external-tools-integration/cadence/virtuoso/skill/layout/cable/spec_templates/nyb_mbuf_spec.cast") )
(defvar nyb_rbuf_spec   strcat( "/nfs/site/disks/wdisk.83/pankala1/sw/sw/cad/external-tools-integration/cadence/virtuoso/skill/layout/cable/spec_templates/nyb_rbuf_spec.cast") )
(defvar nyb_spec        strcat( "/nfs/site/disks/wdisk.83/pankala1/sw/sw/cad/external-tools-integration/cadence/virtuoso/skill/layout/cable/spec_templates/nyb_spec.cast"     ) )

(defvar ts_sbuf_spec    strcat( "/nfs/site/disks/wdisk.83/pankala1/sw/sw/cad/external-tools-integration/cadence/virtuoso/skill/layout/cable/spec_templates/ts_sbuf_spec.cast") )
(defvar ts18_sbuf_spec  strcat( "/nfs/site/disks/wdisk.83/pankala1/sw/sw/cad/external-tools-integration/cadence/virtuoso/skill/layout/cable/spec_templates/ts18_sbuf_spec.cast") )
(defvar ts_mbuf_spec    strcat( "/nfs/site/disks/wdisk.83/pankala1/sw/sw/cad/external-tools-integration/cadence/virtuoso/skill/layout/cable/spec_templates/ts_mbuf_spec.cast") )
(defvar ts_rbuf_spec    strcat( "/nfs/site/disks/wdisk.83/pankala1/sw/sw/cad/external-tools-integration/cadence/virtuoso/skill/layout/cable/spec_templates/ts_rbuf_spec.cast") )
(defvar ts_spec         strcat( "/nfs/site/disks/wdisk.83/pankala1/sw/sw/cad/external-tools-integration/cadence/virtuoso/skill/layout/cable/spec_templates/ts_spec.cast"     ) )
(defvar ts18_spec       strcat( "/nfs/site/disks/wdisk.83/pankala1/sw/sw/cad/external-tools-integration/cadence/virtuoso/skill/layout/cable/spec_templates/ts18_spec.cast"     ) )

(defvar xbus_adp_spec   strcat( "/nfs/site/disks/wdisk.83/pankala1/sw/sw/cad/external-tools-integration/cadence/virtuoso/skill/layout/cable/spec_templates/xbus_adp_spec.cast") )
(defvar xbus_mbuf_spec  strcat( "/nfs/site/disks/wdisk.83/pankala1/sw/sw/cad/external-tools-integration/cadence/virtuoso/skill/layout/cable/spec_templates/xbus_mbuf_spec.cast") )
(defvar xbus_sbuf_spec  strcat( "/nfs/site/disks/wdisk.83/pankala1/sw/sw/cad/external-tools-integration/cadence/virtuoso/skill/layout/cable/spec_templates/xbus_sbuf_spec.cast") )
(defvar xbus_rbuf_spec  strcat( "/nfs/site/disks/wdisk.83/pankala1/sw/sw/cad/external-tools-integration/cadence/virtuoso/skill/layout/cable/spec_templates/xbus_rbuf_spec.cast") )
(defvar xbus_cable_spec strcat( "/nfs/site/disks/wdisk.83/pankala1/sw/sw/cad/external-tools-integration/cadence/virtuoso/skill/layout/cable/spec_templates/xbus_spec.cast"     ) )
(defvar sync_node_spec  strcat( "/nfs/site/disks/wdisk.83/pankala1/sw/sw/cad/external-tools-integration/cadence/virtuoso/skill/layout/cable/spec_templates/sync_node_spec.cast") )

;The CABLE guides should have the following properties
;for the automated Spec/Layout generation scripts to work
;
;       ChannelName     "string"   "INGRESS_SUB[0]"
;       ChannelWidth    "decimal"  33
;       ChannelHops     "decimal"  5
;       ChannelBuf      "string"   "TS"
;       sbuf_orient     "string"   "V"
;       rbuf_orient     "string"   "H"

(defun recurseSpec ( @key (CV (geGetEditCellView)) )
 (let ( guides s )

      guides = setof(s CV~>shapes s~>ChannelName&&s~>ChannelWidth&&s~>ChannelHops)
      println(length(guides))
      foreach(s guides println(s~>ChannelName) createCableSpec(s))

 )
)

(defun createCableSpec ( cableGuide @key (dBuf "NYB") (CV (geGetEditCellView)) (myspec nil)
                        (overwrite nil) (sbuf_orient "H") (rbuf_orient "H"))

 (let ( i_al_fl o_al_fl s guides str flt client_spec p4cmd spec_bundle buf i_as_fl
        i_ar_fl o_ar_fl sbuf_spec_file  sh_sbuf_spec_file  sh_sbuf_dir  i_s_fl xadpL         xadpL xchannelHopsL          adpL_define  adpL_module o_s_fl
        i_ml_fl o_ml_fl mbuf_spec_file  sh_mbuf_spec_file  sh_mbuf_dir  i_m_fl xadpR         xadpR xchannelHopsR          adpR_define  adpR_module o_m_fl
        i_mr_fl o_mr_fl rbuf_spec_file  sh_rbuf_spec_file  sh_rbuf_dir  i_r_fl xchannelHopsL rxchannelSpec xchannelHopsL mbufL_define mbufL_module o_r_fl
        i_c_fl  o_c_fl  cable_spec_file sh_cable_spec_file sh_cable_dir i_c_fl xchannelHopsR txchannelSpec xchannelHopsR mbufR_define mbufR_module
        sbuf_module sbuf_define
        rbuf_module rbuf_define
        mbuf_module mbuf_define
        cable_module cable_define cable_subcells
        spec_root spec_temp
        channelName  channelSBuf sbuf
        channelWidth channelRBuf mbuf channelWidth2
        channelHops  channelBuf
       )

       if(myspec then spec_root = myspec else spec_root =  ( ConfigFileGetValue TheCDSConfigTable "SPEC_DIR" ))
       channelName     =  cableGuide~>ChannelName
       channelWidth    =  cableGuide~>ChannelWidth
       channelHops     =  cableGuide~>ChannelHops
       channelBuf      =  cableGuide~>ChannelBuf
       channelSBuf     =  cableGuide~>ChannelSbufOrient
       channelRBuf     =  cableGuide~>ChannelRbufOrient
       client_spec     =  ( ConfigFileGetValue TheCDSConfigTable "P4CLIENT" )
       channelWidth2   =  round((channelWidth+1)/2)
       xadpL           =  cableGuide~>XBUS_Adapter_L
       xadpR           =  cableGuide~>XBUS_Adapter_R
       xchannelHopsL   =  cableGuide~>XBUS_L_ChannelHops
       xchannelHopsR   =  cableGuide~>XBUS_R_ChannelHops

       if(channelBuf then buf = channelBuf else buf = dBuf)
       if(channelBuf=="DENSE" then buf = "" else buf = strcat(buf "_"))
       when(channelBuf=="TS_18" buf = "TS_" )

       spec_temp = parseString(lowerCase(channelName) "[]")
       if(length(spec_temp)>1
         then
           channelSpec = strcat(car(spec_temp) "_" cadr(spec_temp))
         else
           channelSpec = lowerCase(channelName)
         )
       if(!channelSBuf then sbuf=sbuf_orient else sbuf=channelSBuf)
       if(!channelRBuf then rbuf=rbuf_orient else rbuf=channelRBuf)

      case( channelBuf
        ( "DENSE" || "NYB" || "TS"
          sprintf(sbuf_spec_file   "%s/chip/rrc/util/cable/%sCABLE_SBUF(%d)/%s.cast" spec_root buf channelWidth sbuf)
          sprintf(rbuf_spec_file   "%s/chip/rrc/util/cable/%sCABLE_RBUF(%d)/%s.cast" spec_root buf channelWidth rbuf)
          sprintf(mbuf_spec_file   "%s/chip/rrc/util/cable/%sCABLE_MBUFS(%d,%d)/%s.cast"  spec_root buf channelHops channelWidth2 channelSpec)
          sprintf(cable_spec_file  "%s/chip/rrc/util/cable/%sCABLE(%d,%d)/%s.cast"        spec_root buf channelHops channelWidth  channelSpec)

          sprintf(sh_sbuf_spec_file   "%s/chip/rrc/util/cable/%sCABLE_SBUF\\(%d\\)/%s.cast" spec_root buf channelWidth sbuf)
          sprintf(sh_rbuf_spec_file   "%s/chip/rrc/util/cable/%sCABLE_RBUF\\(%d\\)/%s.cast" spec_root buf channelWidth rbuf)
          sprintf(sh_mbuf_spec_file   "%s/chip/rrc/util/cable/%sCABLE_MBUFS\\(%d,%d\\)/%s.cast"  spec_root buf channelHops channelWidth2 channelSpec)
          sprintf(sh_cable_spec_file  "%s/chip/rrc/util/cable/%sCABLE\\(%d,%d\\)/%s.cast"        spec_root buf channelHops channelWidth  channelSpec)

          sprintf(sh_sbuf_dir   "%s/chip/rrc/util/cable/%sCABLE_SBUF\\(%d\\)/"      spec_root buf channelWidth sbuf)
          sprintf(sh_rbuf_dir   "%s/chip/rrc/util/cable/%sCABLE_RBUF\\(%d\\)/"      spec_root buf channelWidth rbuf)
          sprintf(sh_mbuf_dir   "%s/chip/rrc/util/cable/%sCABLE_MBUFS\\(%d,%d\\)/"  spec_root buf channelHops channelWidth2 channelSpec)
          sprintf(sh_cable_dir  "%s/chip/rrc/util/cable/%sCABLE\\(%d,%d\\)/"        spec_root buf channelHops channelWidth  channelSpec)

          shell(strcat("mkdir -p " sh_sbuf_dir ))
          shell(strcat("mkdir -p " sh_rbuf_dir ))
          shell(strcat("mkdir -p " sh_mbuf_dir ))
          shell(strcat("mkdir -p " sh_cable_dir))

          P4File(sh_sbuf_spec_file  "edit")
          P4File(sh_rbuf_spec_file  "edit")
          P4File(sh_mbuf_spec_file  "edit")
          P4File(sh_cable_spec_file "edit")
         )
        ( "TS_18"
          sprintf(sbuf_spec_file   "%s/chip/rrc/util/cable/%sCABLE_SBUF_18(%d)/%s.cast" spec_root buf channelWidth sbuf)
          sprintf(rbuf_spec_file   "%s/chip/rrc/util/cable/%sCABLE_RBUF(%d)/%s.cast"    spec_root buf channelWidth rbuf)
          sprintf(mbuf_spec_file   "%s/chip/rrc/util/cable/%sCABLE_MBUFS(%d,%d)/%s.cast"  spec_root buf channelHops channelWidth2 channelSpec)
          sprintf(cable_spec_file  "%s/chip/rrc/util/cable/%sCABLE_18(%d,%d)/%s.cast"     spec_root buf channelHops channelWidth  channelSpec)

          sprintf(sh_sbuf_spec_file   "%s/chip/rrc/util/cable/%sCABLE_SBUF_18\\(%d\\)/%s.cast" spec_root buf channelWidth sbuf)
          sprintf(sh_rbuf_spec_file   "%s/chip/rrc/util/cable/%sCABLE_RBUF\\(%d\\)/%s.cast" spec_root buf channelWidth rbuf)
          sprintf(sh_mbuf_spec_file   "%s/chip/rrc/util/cable/%sCABLE_MBUFS\\(%d,%d\\)/%s.cast"  spec_root buf channelHops channelWidth2 channelSpec)
          sprintf(sh_cable_spec_file  "%s/chip/rrc/util/cable/%sCABLE_18\\(%d,%d\\)/%s.cast"        spec_root buf channelHops channelWidth  channelSpec)

          sprintf(sh_sbuf_dir   "%s/chip/rrc/util/cable/%sCABLE_SBUF_18\\(%d\\)/"      spec_root buf channelWidth sbuf)
          sprintf(sh_rbuf_dir   "%s/chip/rrc/util/cable/%sCABLE_RBUF\\(%d\\)/"      spec_root buf channelWidth rbuf)
          sprintf(sh_mbuf_dir   "%s/chip/rrc/util/cable/%sCABLE_MBUFS\\(%d,%d\\)/"  spec_root buf channelHops channelWidth2 channelSpec)
          sprintf(sh_cable_dir  "%s/chip/rrc/util/cable/%sCABLE_18\\(%d,%d\\)/"        spec_root buf channelHops channelWidth  channelSpec)

          shell(strcat("mkdir -p " sh_sbuf_dir ))
          shell(strcat("mkdir -p " sh_rbuf_dir ))
          shell(strcat("mkdir -p " sh_mbuf_dir ))
          shell(strcat("mkdir -p " sh_cable_dir))

          P4File(sh_sbuf_spec_file  "edit")
          P4File(sh_rbuf_spec_file  "edit")
          P4File(sh_mbuf_spec_file  "edit")
          P4File(sh_cable_spec_file "edit")
         )
        ( "XBUS"
          channelName = lowerCase(channelName)
          spec_temp   = parseString( channelName "[]" )
          spec_temp2  = parseString( channelName "_[]" )

          when( nth(0 spec_temp2) == "rx" || nth(0 spec_temp2) == "tx"
             rxchannelSpec = strcat("rx_xbus_port_" cadr(spec_temp))
             txchannelSpec = strcat("tx_xbus_port_" cadr(spec_temp))
             channelSpec   = strcat("xbus_port_"    cadr(spec_temp))
           )
          when( nth(0 parseString( channelName "_[]" )) == "rx"  rxchannelSpec = strcat(car(spec_temp) "_" cadr(spec_temp)))

          sprintf(sbuf_spec_file   "%s/chip/rrc/util/cable/CABLE_SBUF_XbusPortHalf/%s.cast"       spec_root xadpL )
          sprintf(rbuf_spec_file   "%s/chip/rrc/util/cable/CABLE_RBUF_XbusPortHalf/%s.cast"       spec_root xadpR )
          sprintf(mbufL_spec_file  "%s/chip/rrc/util/cable/CABLE_MBUFS_XbusPortHalf(%d)/%s.cast"          spec_root xchannelHopsL txchannelSpec)
          sprintf(mbufR_spec_file  "%s/chip/rrc/util/cable/CABLE_MBUFS_XbusPortHalf(%d)/%s.cast"          spec_root xchannelHopsR rxchannelSpec)
          sprintf(cable_spec_file  "%s/chip/rrc/util/cable/CABLE_XbusPort(%d,%d)/%s.cast"                 spec_root xchannelHopsL xchannelHopsR channelSpec)

          sprintf(sh_adpL_spec_file   "%s/chip/rrc/util/cable/CABLE_SBUF_XbusPortHalf/%s.cast"      spec_root xadpL )
          sprintf(sh_adpR_spec_file   "%s/chip/rrc/util/cable/CABLE_RBUF_XbusPortHalf/%s.cast"      spec_root xadpR )
          sprintf(sh_mbufL_spec_file  "%s/chip/rrc/util/cable/CABLE_MBUFS_XbusPortHalf\\(%d\\)/%s.cast"         spec_root xchannelHopsL txchannelSpec)
          sprintf(sh_mbufR_spec_file  "%s/chip/rrc/util/cable/CABLE_MBUFS_XbusPortHalf\\(%d\\)/%s.cast"         spec_root xchannelHopsR rxchannelSpec)
          sprintf(sh_cable_spec_file  "%s/chip/rrc/util/cable/CABLE_XbusPort\\(%d,%d\\)/%s.cast"            spec_root xchannelHopsL xchannelHopsR channelSpec)

          sprintf(sh_adpL_dir   "%s/chip/rrc/util/cable/CABLE_SBUF_XbusPortHalf/" spec_root )
          sprintf(sh_adpR_dir   "%s/chip/rrc/util/cable/CABLE_RBUF_XbusPortHalf/" spec_root )
          sprintf(sh_mbufL_dir  "%s/chip/rrc/util/cable/CABLE_MBUFS_XbusPortHalf\\(%d\\)/"    spec_root xchannelHopsL )
          sprintf(sh_mbufR_dir  "%s/chip/rrc/util/cable/CABLE_MBUFS_XbusPortHalf\\(%d\\)/"    spec_root xchannelHopsR )
          sprintf(sh_cable_dir  "%s/chip/rrc/util/cable/CABLE_XbusPort\\(%d,%d\\)/"       spec_root xchannelHopsL xchannelHopsR )

          shell(strcat("mkdir -p " sh_adpL_dir ))
          shell(strcat("mkdir -p " sh_adpR_dir ))
          shell(strcat("mkdir -p " sh_mbufL_dir))
          shell(strcat("mkdir -p " sh_mbufR_dir))
          shell(strcat("mkdir -p " sh_cable_dir))

          P4File(sh_adpL_spec_file   "edit")
          P4File(sh_adpR_spec_file   "edit")
          P4File(sh_mbufL_spec_file  "edit")
          P4File(sh_mbufR_spec_file  "edit")
          P4File(sh_cable_spec_file  "edit")
         )
        ( "SYNC_NODE"
          sprintf(cable_spec_file    "%s/chip/rrc/util/cable/%sCABLE(%d,%d)/%s.cast"     spec_root buf channelHops channelWidth  channelSpec)
          sprintf(sh_cable_spec_file "%s/chip/rrc/util/cable/%sCABLE\\(%d,%d\\)/%s.cast" spec_root buf channelHops channelWidth  channelSpec)
          sprintf(sh_cable_dir       "%s/chip/rrc/util/cable/%sCABLE\\(%d,%d\\)/"        spec_root buf channelHops channelWidth  channelSpec)

          shell(strcat("mkdir -p " sh_cable_dir))

          P4File(sh_cable_spec_file "edit")
         )
       )

;       when( t ; overwrite
;              P4File(sh_sbuf_spec_file  "edit")
;              P4File(sh_rbuf_spec_file  "edit")
;              P4File(sh_mbuf_spec_file  "edit")
;              P4File(sh_cable_spec_file "edit")
;            )
       case( channelBuf
        ( channelBuf == "NYB"
            i_s_fl = infile(nyb_sbuf_spec)
            i_m_fl = infile(nyb_mbuf_spec)
            i_r_fl = infile(nyb_rbuf_spec)
            i_c_fl = infile(nyb_spec     )
           )
        ( channelBuf == "TS"
            i_s_fl = infile(ts_sbuf_spec)
            i_m_fl = infile(ts_mbuf_spec)
            i_r_fl = infile(ts_rbuf_spec)
            i_c_fl = infile(ts_spec     )
           )
        ( channelBuf == "TS_18"
            i_s_fl = infile(ts18_sbuf_spec)
            i_m_fl = infile(ts_mbuf_spec)
            i_r_fl = infile(ts_rbuf_spec)
            i_c_fl = infile(ts18_spec     )
           )
        ( channelBuf == "DENSE"
            i_s_fl = infile(dense_sbuf_spec)
            i_m_fl = infile(dense_mbuf_spec)
            i_r_fl = infile(dense_rbuf_spec)
            i_c_fl = infile(dense_spec     )
           )
        ( channelBuf == "XBUS"
            i_as_fl = infile(xbus_sbuf_spec )
            i_ar_fl = infile(xbus_rbuf_spec )
            i_ml_fl = infile(xbus_mbuf_spec)
            i_mr_fl = infile(xbus_mbuf_spec)
            i_c_fl  = infile(xbus_cable_spec)
           )
        ( channelBuf == "SYNC_NODE"
            i_c_fl = infile(sync_node_spec)
           )
        )
       case( channelBuf
         ( "DENSE" || "NYB" || "TS"
          o_s_fl = outfile(sbuf_spec_file )
          o_m_fl = outfile(mbuf_spec_file )
          o_r_fl = outfile(rbuf_spec_file )
          o_c_fl = outfile(cable_spec_file)

          println(sbuf_spec_file )
          println(rbuf_spec_file )
          println(mbuf_spec_file )
          println(cable_spec_file)

          sbuf_module = car(modBufSpecString(buf "SBUF"  strcat("" sbuf) channelHops channelWidth))
          rbuf_module = car(modBufSpecString(buf "RBUF"  strcat("" rbuf) channelHops channelWidth))
          mbuf_module = car(modBufSpecString(buf "MBUFS" channelSpec          channelHops channelWidth))

          sbuf_define = cadr(modBufSpecString(buf "SBUF"  strcat("" sbuf) channelHops channelWidth))
          rbuf_define = cadr(modBufSpecString(buf "RBUF"  strcat("" rbuf) channelHops channelWidth))
          mbuf_define = cadr(modBufSpecString(buf "MBUFS" channelSpec          channelHops channelWidth))

          cable_module   = nth(0 modCabSpecString(buf channelHops channelWidth channelSpec  strcat("" sbuf) strcat("" rbuf) ?ChannelBuf channelBuf) )
          cable_define   = nth(1 modCabSpecString(buf channelHops channelWidth channelSpec  strcat("" sbuf) strcat("" rbuf) ?ChannelBuf channelBuf) )
          cable_subcells = nth(2 modCabSpecString(buf channelHops channelWidth channelSpec  strcat("" sbuf) strcat("" rbuf) ?ChannelBuf channelBuf) )
         )
         ( "TS_18"
          o_s_fl = outfile(sbuf_spec_file )
          o_m_fl = outfile(mbuf_spec_file )
          o_r_fl = outfile(rbuf_spec_file )
          o_c_fl = outfile(cable_spec_file)

          println(sbuf_spec_file )
          println(rbuf_spec_file )
          println(mbuf_spec_file )
          println(cable_spec_file)

          sbuf_module = car(modBufSpecString(buf "SBUF_18"  strcat("" sbuf) channelHops channelWidth))
          rbuf_module = car(modBufSpecString(buf "RBUF"  strcat("" rbuf) channelHops channelWidth))
          mbuf_module = car(modBufSpecString(buf "MBUFS" channelSpec          channelHops channelWidth))

          sbuf_define = cadr(modBufSpecString(buf "SBUF_18"  strcat("" sbuf) channelHops channelWidth))
          rbuf_define = cadr(modBufSpecString(buf "RBUF"  strcat("" rbuf) channelHops channelWidth))
          mbuf_define = cadr(modBufSpecString(buf "MBUFS" channelSpec          channelHops channelWidth))

          cable_module   = nth(0 modCabSpecString(buf channelHops channelWidth channelSpec  strcat("" sbuf) strcat("" rbuf) ?ChannelBuf channelBuf) )
          cable_define   = nth(1 modCabSpecString(buf channelHops channelWidth channelSpec  strcat("" sbuf) strcat("" rbuf) ?ChannelBuf channelBuf) )
          cable_subcells = nth(2 modCabSpecString(buf channelHops channelWidth channelSpec  strcat("" sbuf) strcat("" rbuf) ?ChannelBuf channelBuf) )
         )
         ( "XBUS"
          o_al_fl = outfile(sbuf_spec_file  )
          o_ar_fl = outfile(rbuf_spec_file  )
          o_ml_fl = outfile(mbufL_spec_file )
          o_mr_fl = outfile(mbufR_spec_file )
          o_c_fl  = outfile(cable_spec_file )

          println(sbuf_spec_file   )
          println(rbuf_spec_file   )
          println(mbufL_spec_file  )
          println(mbufR_spec_file  )
          println(cable_spec_file  )

          adpL_module  = car(modBufSpecString( "SBUF" "XBUS" xadpL xchannelHopsL "" ?adp t))
          adpR_module  = car(modBufSpecString( "RBUF" "XBUS" xadpR xchannelHopsR "" ?adp t))
          mbufL_module = car(modBufSpecString( "" "XBUS" txchannelSpec xchannelHopsL ""))
          mbufR_module = car(modBufSpecString( "" "XBUS" rxchannelSpec xchannelHopsR ""))

           adpL_define  = cadr(modBufSpecString( "SBUF" "XBUS" xadpL xchannelHopsL         "" ?adp t))
           adpR_define  = cadr(modBufSpecString( "RBUF" "XBUS" xadpR xchannelHopsR         "" ?adp t))
          mbufL_define  = cadr(modBufSpecString( "" "XBUS" txchannelSpec xchannelHopsL ""))
          mbufR_define  = cadr(modBufSpecString( "" "XBUS" rxchannelSpec xchannelHopsR ""))

          cable_module   = nth(0 modCabSpecString( "XBUS" list(xchannelHopsL xchannelHopsR) "" channelSpec  list(xadpL xadpR) list(rxchannelSpec txchannelSpec) ?ChannelBuf channelBuf ) )
          cable_define   = nth(1 modCabSpecString( "XBUS" list(xchannelHopsL xchannelHopsR) "" channelSpec  list(xadpL xadpR) list(rxchannelSpec txchannelSpec) ?ChannelBuf channelBuf ) )
          cable_subcells = nth(2 modCabSpecString( "XBUS" list(xchannelHopsL xchannelHopsR) "" channelSpec  list(xadpL xadpR) list(rxchannelSpec txchannelSpec) ?ChannelBuf channelBuf ) )
         )
        ( "SYNC_NODE"
          o_c_fl = outfile(cable_spec_file)

          println(cable_spec_file)

          cable_module   = nth(0 modBufSpecString( channelBuf channelBuf channelSpec channelHops channelWidth ))
          cable_define   = nth(1 modBufSpecString( channelBuf channelBuf channelSpec channelHops channelWidth ))
          cable_subcells = ""
        )
       )

   case( channelBuf
     (  "DENSE" || "NYB" || "TS" || "TS_18"
       while( gets(str i_s_fl)
          strparts=parseString(str)
          when( car(strparts) == "module"
             str = sbuf_module
             )
          when( car(strparts) == "define"
             str = sbuf_define
             )
          fprintf(o_s_fl "%s" str)
       )
       close(i_s_fl)
       close(o_s_fl)

       while( gets(str i_m_fl)
          strparts=parseString(str)
          when( car(strparts) == "module"
             str = mbuf_module
             )
          when( car(strparts) == "define"
             str = mbuf_define
             )
          fprintf(o_m_fl "%s" str)
       )
       close(i_m_fl)
       close(o_m_fl)

       while( gets(str i_r_fl)
          strparts=parseString(str)
          when( car(strparts) == "module"
             str = rbuf_module
             )
          when( car(strparts) == "define"
             str = rbuf_define
             )
          fprintf(o_r_fl "%s" str)
       )
       close(i_r_fl)
       close(o_r_fl)

       while( gets(str i_c_fl)
          strparts=parseString(str)
          when( car(strparts) == "module"
             str = cable_module
             )
          when( car(strparts) == "define"
             str = cable_define
             )
          when( car(strparts) == "FIXME"
             str = cable_subcells
             )
          fprintf(o_c_fl "%s" str)
       )
       close(i_c_fl)
       close(o_c_fl)
      )
     ( "SYNC_NODE"
       while( gets(str i_c_fl)
          strparts=parseString(str)
          when( car(strparts) == "module"
             str = cable_module
             )
          when( car(strparts) == "define"
             str = cable_define
             )
          when( car(strparts) == "FIXME"
             str = cable_subcells
             )
          fprintf(o_c_fl "%s" str)
       )
       close(i_c_fl)
       close(o_c_fl)
     )
     (  "XBUS"
       println("helo")
       while( gets(str i_as_fl)
          strparts=parseString(str)
          when( car(strparts) == "module"
             str = adpL_module
             )
          when( car(strparts) == "define"
             str = adpL_define
             )
          fprintf(o_al_fl "%s" str)
       )
       close(i_as_fl)
       close(o_al_fl)

       while( gets(str i_ar_fl)
          strparts=parseString(str)
          when( car(strparts) == "module"
             str = adpR_module
             )
          when( car(strparts) == "define"
             str = adpR_define
             )
          fprintf(o_ar_fl "%s" str)
       )
       close(i_ar_fl)
       close(o_ar_fl)

       while( gets(str i_ml_fl)
          strparts=parseString(str)
          when( car(strparts) == "module"
             str = mbufL_module
             )
          when( car(strparts) == "define"
             str = mbufL_define
             )
          fprintf(o_ml_fl "%s" str)
       )
       close(i_ml_fl)
       close(o_ml_fl)

       while( gets(str i_mr_fl)
          strparts=parseString(str)
          when( car(strparts) == "module"
             str = mbufR_module
             )
          when( car(strparts) == "define"
             str = mbufR_define
             )
          fprintf(o_mr_fl "%s" str)
       )
       close(i_mr_fl)
       close(o_mr_fl)

       while( gets(str i_c_fl)
          strparts=parseString(str)
          when( car(strparts) == "module"
             str = cable_module
             )
          when( car(strparts) == "define"
             str = cable_define
             )
          when( car(strparts) == "FIXME"
             str = cable_subcells
             )
          fprintf(o_c_fl "%s" str)
       )
       close(i_c_fl)
       close(o_c_fl)
      )
   )

   case( channelBuf
     (  "DENSE" || "NYB" || "TS" || "TS_18"
       P4File(sh_sbuf_spec_file  "revert -a")
       P4File(sh_rbuf_spec_file  "revert -a")
       P4File(sh_mbuf_spec_file  "revert -a")
       P4File(sh_cable_spec_file "revert -a")

       P4File(sh_sbuf_spec_file  "add")
       P4File(sh_rbuf_spec_file  "add")
       P4File(sh_mbuf_spec_file  "add")
       P4File(sh_cable_spec_file "add")
      )
    (  "SYNC_NODE"
       P4File(sh_cable_spec_file "revert -a")
       P4File(sh_cable_spec_file "add")
      )
    ( "XBUS"
       P4File(sh_adpL_spec_file  "revert -a")
       P4File(sh_adpR_spec_file  "revert -a")
       P4File(sh_mbufL_spec_file "revert -a")
       P4File(sh_mbufR_spec_file "revert -a")
       P4File(sh_cable_spec_file "revert -a")

       P4File(sh_adpL_spec_file  "add")
       P4File(sh_adpR_spec_file  "add")
       P4File(sh_mbufL_spec_file "add")
       P4File(sh_mbufR_spec_file "add")
       P4File(sh_cable_spec_file "add")
      )
    )
t
 )
)

(defun modBufSpecString (buf type subtype Hops W @key (adp nil))
  (let ( cell module define )

    case( type
      ( "SBUF" || "RBUF" || "SBUF_18"
       sprintf(cell "chip.rrc.util.cable.%sCABLE_%s(%d)" buf type W)
      )
      ( "MBUFS"
       sprintf(cell "chip.rrc.util.cable.%sCABLE_%s(%d,%d)" buf type Hops round((W+1)/2))
      )
      ( "XBUS"
        when( !adp sprintf(cell "chip.rrc.util.cable.CABLE_MBUFS_XbusPortHalf(%d)" Hops) )
        when(  adp sprintf(cell "chip.rrc.util.cable.CABLE_%s_XbusPortHalf" buf ) )
      )
      ( "SYNC_NODE"
       sprintf(cell "chip.rrc.util.cable.%s_CABLE(%d,%d)" buf Hops W)
      )
     )

    println(cell)
    module = strcat("module " cell ";\n")
    sprintf(define "define \"%s\"() <+ standard.process.standard_layout_cell <: %s { \n" subtype cell)

    list(module define)
 )
)

(defun modCabSpecString (buf Hops W subtype sbuf rbuf @key ( ChannelBuf "" ))
  (let ( adpL_subcells mbufLHops cell module define subcells W2 op
         adpR_subcells mbufRHops s_subcells
         mL_subcells   adpLSpec  r_subcells
         mR_subcells   adpRSpec  m_subcells  )

    case( ChannelBuf
      ( "DENSE" || "NYB" || "TS"
        sprintf(cell "chip.rrc.util.cable.%sCABLE(%d,%d)" buf Hops W)
        W2 = round((W+1)/2)
        module = strcat("module " cell ";\n")
        sprintf(define "define \"%s\"() <+ standard.process.standard_layout_cell <: %s { \n" subtype cell)
        sprintf( s_subcells "      chip.rrc.util.cable.%sCABLE_SBUF(%d) :>     \n        chip.rrc.util.cable.%sCABLE_SBUF(%d).%s sbuf;      \n" buf W buf W sbuf)
        sprintf( r_subcells "      chip.rrc.util.cable.%sCABLE_RBUF(%d) :>     \n        chip.rrc.util.cable.%sCABLE_RBUF(%d).%s rbuf;      \n" buf W buf W rbuf)
        sprintf( m_subcells "      chip.rrc.util.cable.%sCABLE_MBUFS(%d,%d) :> \n        chip.rrc.util.cable.%sCABLE_MBUFS(%d,%d).%s mbuf;  \n" buf Hops W2 buf Hops W2 subtype)
        op = list(module define strcat(s_subcells m_subcells r_subcells))
      )
      ( "TS_18"
        sprintf(cell "chip.rrc.util.cable.%sCABLE_18(%d,%d)" buf Hops W)
        W2 = round((W+1)/2)
        module = strcat("module " cell ";\n")
        sprintf(define "define \"%s\"() <+ standard.process.standard_layout_cell <: %s { \n" subtype cell)
        sprintf( s_subcells "      chip.rrc.util.cable.%sCABLE_SBUF_18(%d) :>     \n        chip.rrc.util.cable.%sCABLE_SBUF_18(%d).%s sbuf;      \n" buf W buf W sbuf)
        sprintf( r_subcells "      chip.rrc.util.cable.%sCABLE_RBUF(%d) :>     \n        chip.rrc.util.cable.%sCABLE_RBUF(%d).%s rbuf;      \n" buf W buf W rbuf)
        sprintf( m_subcells "      chip.rrc.util.cable.%sCABLE_MBUFS(%d,%d) :> \n        chip.rrc.util.cable.%sCABLE_MBUFS(%d,%d).%s mbuf;  \n" buf Hops W2 buf Hops W2 subtype)
        op = list(module define strcat(s_subcells m_subcells r_subcells))
      )
      ( "XBUS"
        mbufLHops = cadr(Hops)
        mbufRHops =  car(Hops)
        adpLSpec  =  car(sbuf)
        adpRSpec  = cadr(sbuf)
        mbufLSpec  =  car(rbuf)
        mbufRSpec  = cadr(rbuf)
        sprintf(cell "chip.rrc.util.cable.CABLE_XbusPort(%d,%d)" mbufRHops mbufLHops)
        module = strcat("module " cell ";\n")
        sprintf(define "define \"%s\"() <+ standard.process.standard_layout_cell <: %s { \n" subtype cell)

        sprintf( adpL_subcells "      chip.rrc.util.cable.CABLE_SBUF_XbusPortHalf :>         \n        chip.rrc.util.cable.CABLE_SBUF_XbusPortHalf.%s sbufR;   \n" adpLSpec )
        sprintf( adpR_subcells "      chip.rrc.util.cable.CABLE_RBUF_XbusPortHalf :>         \n        chip.rrc.util.cable.CABLE_RBUF_XbusPortHalf.%s rbufL;   \n" adpRSpec )
        sprintf( mL_subcells   "      chip.rrc.util.cable.CABLE_MBUFS_XbusPortHalf(%d):>     \n        chip.rrc.util.cable.CABLE_MBUFS_XbusPortHalf(%d).%s    cabR;   \n" mbufLHops mbufLHops mbufLSpec )
        sprintf( mR_subcells   "      chip.rrc.util.cable.CABLE_MBUFS_XbusPortHalf(%d):>     \n        chip.rrc.util.cable.CABLE_MBUFS_XbusPortHalf(%d).%s    cabL;   \n" mbufRHops mbufRHops mbufRSpec )

        op = list(module define strcat(adpL_subcells adpR_subcells mL_subcells mR_subcells))
      )
     )

op
 )
)

(defun P4File (filename action)
 (let (cmd)
  if( action != "submit"
    then
      sprintf(cmd "p4 -c %s %s %s"
                  ( ConfigFileGetValue TheCDSConfigTable "P4CLIENT" )
                  action
                  filename
              )
    else
      sprintf(cmd "p4 -c %s %s -d %s %s"
                  ( ConfigFileGetValue TheCDSConfigTable "P4CLIENT" )
                  action
                  "\"Automated cable spec check-in.\""
                  filename
              )
     )

    println(cmd)
      shell(cmd)
t
 )
)

(defun invertPathDir (@key (shape car(geGetSelectedSet())) (CV (geGetEditCellView)))
 (let ( inv_pts I )

   inv_pts = list(nth(0 shape~>points))
   for(I 1 shape~>nPoints-1 inv_pts = cons(nth(I shape~>points) inv_pts))
   new = dbCreatePath(CV shape~>lpp inv_pts shape~>width)
   when(shape~>prop  dbCopyProp(shape new))
   dbDeleteObject(shape)

 )
)

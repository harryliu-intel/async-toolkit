; Copyright (c) 2025 Intel Corporation.  All rights reserved.  See the file COPYRIGHT for more information.
; SPDX-License-Identifier: Apache-2.0

(defun MakeCtree2 (CellView ViewName)
	(let (text parameter1 parameter2 parameter3 parameter4 cordnx1 cordnx2 cordpx1 cordpx2 cordR0x1 cordR0x2 cordR0y2 PolyM1x2 ActualPolyM1x2 PolyM1x1 ActualPolyM1x1 PWidth NWidth cordx1 cordx2 INST SHAPE VIA i k)
	fl = infile("Parameter.txt")
	k=0
	i=0
	while( gets(k fl) != nil
  	text = parseString( k " \n")
	parameter1 = nth(0 text)
	parameter2 = nth(1 text)
	parameter3 = nth(2 text)
	parameter4 = nth(3 text)
	foreach(INST CellView->instances
		(let (N P Nparam Pparam paraN1 paraN2 paraP1 paraP2)
		when( (INST->name==parameter1) && (INST->cellName=="gate.INV.0-L1_1-R")
		N=evalstring(parameter3)
		Nparam=N/1000000
		P=evalstring(parameter4)
		Pparam=P/1000000
		when((INST->cellName=="gate.INV.0-L1_1-R") && (INST->name=="x")
			NWidth=N)
		dbReplaceProp(INST "NW1" "float" Nparam)
		dbReplaceProp(INST "PW1" "float" Pparam)
		)
		when( ( (INST->cellName=="stack.NMOS_CHAIN_2.0-L1-R") || (INST->cellName=="stack.PMOS_CHAIN_2.0-L1-R"))
		paraN1 = strcat( parameter1 "." "N1")
		paraN2 = strcat( parameter1 "." "N2")
		paraP1 = strcat( parameter1 "." "P1")
		paraP2 = strcat( parameter1 "." "P2")
		when(((INST->name==paraN1) || (INST->name==paraP1) || (INST->name==paraN2) || (INST->name==paraP2))
		N=evalstring(parameter3)
		Nparam=N/2000000
		P=evalstring(parameter4)
		Pparam=P/2000000
		when((INST->cellName=="stack.PMOS_CHAIN_2.0-L1-R") && (INST->name=="b.P1")
			PWidth=(P/2))
		dbReplaceProp(INST "NW2" "float" Nparam)
		dbReplaceProp(INST "PW2" "float" Pparam)
		))
	)))
; Calculates the XY origin and bBox to move instances w.r.t the new spec
	foreach(INST CellView->instances
		(let (cordNx cordNx1 cordNx2 cordPx cordPx1 cordPx2 xy1 xy2 XY bx1 bx2 by1 by2 diff)
		xy1=car(INST~>xy)
		xy2=cadr(INST~>xy)
		bx1=caar(INST~>bBox)
		by1=cadar(INST~>bBox)
		bx2=caadr(INST~>bBox)
		by2=cadadr(INST~>bBox)
		when(((INST->cellName=="stack.NMOS_CHAIN_2.0-L1-R") && (INST->name=="b.N1"))
			cordNx=caar(INST~>bBox)
			cordNx1=cordNx+0.02
			cordnx1=cordNx1
			cordNx2=cordNx1-0.06
			cordnx2=cordNx2)
		when(((INST->cellName=="stack.PMOS_CHAIN_2.0-L1-R") && (INST->name=="b.P1"))
			cordPx=caadr(INST~>bBox)
			cordPx1=cordPx-0.02
			cordpx1=cordPx1
			cordPx2=cordPx1+0.06
			cordpx2=cordPx2)
		when(((INST->cellName=="gate.INV.0-L1_1-R") && (INST->name=="x"))
			cordR0x1=caar(INST~>bBox)
			cordR0x2=caadr(INST~>bBox)
			cordR0y2=cadadr(INST~>bBox))
		when((INST~>cellName=="M1_POLYmin")&&xy2==1.105&&xy1==0.11
			PolyM1x2=caadr(INST~>bBox))
		when((INST~>cellName=="M1_POLYmin")&&xy2==1.235&&xy1==1.19
			PolyM1x1=caar(INST~>bBox))
		))

	foreach(INST CellView->instances
		(let (cordNx cordNx1 cordNx2 cordPx cordPx1 cordPx2 xy1 xy2 XY bx1 bx2 by1 by2 diff)
		xy1=car(INST~>xy)
		xy2=cadr(INST~>xy)
		bx1=caar(INST~>bBox)
		by1=cadar(INST~>bBox)
		bx2=caadr(INST~>bBox)
		by2=cadadr(INST~>bBox)
		when((INST~>cellName=="M1_POLYmin")&&((xy2==1.105&&xy1==0.11)||(xy2==1.365&&xy1==0.11))
		when((cordnx1+0.06)-(PolyM1x2-0.03)<0.06
		XY=(cordnx1-0.04:xy2))
		when((cordnx1+0.06)-(PolyM1x2-0.03)>=0.06
		XY=(xy1:xy2))
		ActualPolyM1x2=car(XY)
		dbSet(INST XY "xy"))
		when((INST~>cellName=="M1_POLYmin")&&((xy2==1.235&&xy1==1.19)||(xy2==1.495&&xy1==1.19))
		when((PWidth<=0.21)
		when((PolyM1x1+0.03)-(cordpx1-0.06)<0.06
		XY=(cordpx1+0.04:xy2))
		when((PolyM1x1+0.03)-(cordpx1-0.06)>=0.06
		XY=(xy1:xy2)))
		when((PWidth>0.21)
		XY=(cordpx1+0.15:xy2))
		ActualPolyM1x1=car(XY)
		ActualPassPolyM1x1=ActualPolyM1x1
		dbSet(INST XY "xy"))
		when(((INST->cellName=="gate.INV.0-L1_1-R") && (INST->name=="x"))
		when(cordR0y2==2.95
			when(NWidth/8>=0.21
			dbReplaceProp(INST "n_contact_offset" "float" 0.06))
			when(NWidth/8<0.21
			dbReplaceProp(INST "n_contact_offset" "float" (0.47-0.2-(NWidth/8))))
			cordx1=caar(INST~>bBox)
			cordx2=caadr(INST~>bBox)
		        dbCreateParamInstByMasterName(CellView "tsmc28" "M2_M1_2cut_p1_2" "layout" nil (0.455:2.34) "R0" 1
	               list( list("column" "int" 1)
                     list("row" "int" 1)
                     list("layer1YEnclosure" "float" 0.005)
                     list("layer1XEnclosure" "float" 0.04)
                     list("layer2YEnclosure" "float" 0.03)
                     list("layer2XEnclosure" "float" 0.015) ) )
		        dbCreateParamInstByMasterName(CellView "tsmc28" "M2_M1_2cut_p1_2" "layout" nil (0.455:2.6) "R0" 1
	               list( list("column" "int" 1)
                     list("row" "int" 1)
                     list("layer1YEnclosure" "float" 0.005)
                     list("layer1XEnclosure" "float" 0.04)
                     list("layer2YEnclosure" "float" 0.03)
                     list("layer2XEnclosure" "float" 0.015) ) )
		        dbCreateParamInstByMasterName(CellView "tsmc28" "M2_M1_2cut_p1_2" "layout" nil (0.455:2.86) "R0" 1
	               list( list("column" "int" 1)
                     list("row" "int" 1)
                     list("layer1YEnclosure" "float" 0.005)
                     list("layer1XEnclosure" "float" 0.04)
                     list("layer2YEnclosure" "float" 0.03)
                     list("layer2XEnclosure" "float" 0.015) ) )
		        dbCreateParamInstByMasterName(CellView "tsmc28" "M2_M1_2cut_p1_2" "layout" nil (0.845:2.34) "R0" 1
	               list( list("column" "int" 1)
                     list("row" "int" 1)
                     list("layer1YEnclosure" "float" 0.005)
                     list("layer1XEnclosure" "float" 0.04)
                     list("layer2YEnclosure" "float" 0.03)
                     list("layer2XEnclosure" "float" 0.015) ) )
		        dbCreateParamInstByMasterName(CellView "tsmc28" "M2_M1_2cut_p1_2" "layout" nil (0.845:2.6) "R0" 1
	               list( list("column" "int" 1)
                     list("row" "int" 1)
                     list("layer1YEnclosure" "float" 0.005)
                     list("layer1XEnclosure" "float" 0.04)
                     list("layer2YEnclosure" "float" 0.03)
                     list("layer2XEnclosure" "float" 0.015) ) )
		        dbCreateParamInstByMasterName(CellView "tsmc28" "M2_M1_2cut_p1_2" "layout" nil (0.845:2.86) "R0" 1
	               list( list("column" "int" 1)
                     list("row" "int" 1)
                     list("layer1YEnclosure" "float" 0.005)
                     list("layer1XEnclosure" "float" 0.04)
                     list("layer2YEnclosure" "float" 0.03)
                     list("layer2XEnclosure" "float" 0.015) ) ))
		when((cordR0y2==2.82)||(cordR0y2==2.69)
			when((cordR0y2==2.82)
			when(NWidth/7>=0.21
			dbReplaceProp(INST "n_contact_offset" "float" 0.06))
			when(NWidth/7<0.21
			dbReplaceProp(INST "n_contact_offset" "float" (0.47-0.2-(NWidth/7))))
			cordx1=caar(INST~>bBox)
			cordx2=caadr(INST~>bBox))
			when((cordR0y2==2.69)
			when(NWidth/6>=0.21
			dbReplaceProp(INST "n_contact_offset" "float" 0.06))
			when(NWidth/6<0.21
			dbReplaceProp(INST "n_contact_offset" "float" (0.47-0.2-(NWidth/6))))
			cordx1=caar(INST~>bBox)
			cordx2=caadr(INST~>bBox))
		        dbCreateParamInstByMasterName(CellView "tsmc28" "M2_M1_2cut_p1_2" "layout" nil (0.455:2.34) "R0" 1
	               list( list("column" "int" 1)
                     list("row" "int" 1)
                     list("layer1YEnclosure" "float" 0.005)
                     list("layer1XEnclosure" "float" 0.04)
                     list("layer2YEnclosure" "float" 0.03)
                     list("layer2XEnclosure" "float" 0.015) ) )
		        dbCreateParamInstByMasterName(CellView "tsmc28" "M2_M1_2cut_p1_2" "layout" nil (0.455:2.6) "R0" 1
	               list( list("column" "int" 1)
                     list("row" "int" 1)
                     list("layer1YEnclosure" "float" 0.005)
                     list("layer1XEnclosure" "float" 0.04)
                     list("layer2YEnclosure" "float" 0.03)
                     list("layer2XEnclosure" "float" 0.015) ) )
		        dbCreateParamInstByMasterName(CellView "tsmc28" "M2_M1_2cut_p1_2" "layout" nil (0.845:2.34) "R0" 1
	               list( list("column" "int" 1)
                     list("row" "int" 1)
                     list("layer1YEnclosure" "float" 0.005)
                     list("layer1XEnclosure" "float" 0.04)
                     list("layer2YEnclosure" "float" 0.03)
                     list("layer2XEnclosure" "float" 0.015) ) )
		        dbCreateParamInstByMasterName(CellView "tsmc28" "M2_M1_2cut_p1_2" "layout" nil (0.845:2.6) "R0" 1
	               list( list("column" "int" 1)
                     list("row" "int" 1)
                     list("layer1YEnclosure" "float" 0.005)
                     list("layer1XEnclosure" "float" 0.04)
                     list("layer2YEnclosure" "float" 0.03)
                     list("layer2XEnclosure" "float" 0.015) ) ))
		when((cordR0y2==2.56)||(cordR0y2==2.43)
			when((cordR0y2==2.56)
			when(NWidth/5>=0.21
			dbReplaceProp(INST "n_contact_offset" "float" 0.06))
			when(NWidth/5<0.21
			dbReplaceProp(INST "n_contact_offset" "float" (0.47-0.2-(NWidth/5))))
			cordx1=caar(INST~>bBox)
			cordx2=caadr(INST~>bBox))
			when((cordR0y2==2.43)
			when(NWidth/4>=0.21
			dbReplaceProp(INST "n_contact_offset" "float" 0.06))
			when(NWidth/4<0.21
			dbReplaceProp(INST "n_contact_offset" "float" (0.47-0.2-(NWidth/4))))
			cordx1=caar(INST~>bBox)
			cordx2=caadr(INST~>bBox))
		        dbCreateParamInstByMasterName(CellView "tsmc28" "M2_M1_2cut_p1_2" "layout" nil (0.455:2.34) "R0" 1
	               list( list("column" "int" 1)
                     list("row" "int" 1)
                     list("layer1YEnclosure" "float" 0.005)
                     list("layer1XEnclosure" "float" 0.04)
                     list("layer2YEnclosure" "float" 0.03)
                     list("layer2XEnclosure" "float" 0.015) ) )
		        dbCreateParamInstByMasterName(CellView "tsmc28" "M2_M1_2cut_p1_2" "layout" nil (0.845:2.34) "R0" 1
	               list( list("column" "int" 1)
                     list("row" "int" 1)
                     list("layer1YEnclosure" "float" 0.005)
                     list("layer1XEnclosure" "float" 0.04)
                     list("layer2YEnclosure" "float" 0.03)
                     list("layer2XEnclosure" "float" 0.015) ) ))
		when((cordR0y2==2.3)||(cordR0y2==2.17)
			when((cordR0y2==2.3)
			when(NWidth/3>=0.21
			dbReplaceProp(INST "n_contact_offset" "float" 0.06))
			when(NWidth/3<0.21
			dbReplaceProp(INST "n_contact_offset" "float" (0.47-0.2-(NWidth/3))))
			cordx1=caar(INST~>bBox)
			cordx2=caadr(INST~>bBox))
			when((cordR0y2==2.17)
			when(NWidth/2>=0.21
			dbReplaceProp(INST "n_contact_offset" "float" 0.06))
			when(NWidth/2<0.21
			dbReplaceProp(INST "n_contact_offset" "float" (0.47-0.2-(NWidth/2))))
			cordx1=caar(INST~>bBox)
			cordx2=caadr(INST~>bBox)))
		when(cordR0y2==2.04
			when(NWidth>=0.21
			dbReplaceProp(INST "n_contact_offset" "float" 0.06))
			when(NWidth<0.21
			dbReplaceProp(INST "n_contact_offset" "float" (0.47-0.2-NWidth)))
			when((INST~>cellName=="M2_M1_2cut_p1_2")&&((xy1==0.455&&xy2==2.08)||(xy1==0.845&&xy2==2.08))
			dbDeleteObject(INST))
			cordx1=caar(INST~>bBox)
			cordx2=caadr(INST~>bBox)))
		))

	foreach(INST CellView->instances
		(let (cordNx cordNx1 cordNx2 cordPx cordPx1 cordPx2 xy1 xy2 XY bx1 bx2 by1 by2 diff)
		xy1=car(INST~>xy)
		xy2=cadr(INST~>xy)
		bx1=caar(INST~>bBox)
		by1=cadar(INST~>bBox)
		bx2=caadr(INST~>bBox)
		by2=cadadr(INST~>bBox)
		when((INST->cellName=="stack.PPLUG.0")&&(xy1==1.13&&xy2==0.485)
		when((cordx2>=ActualPolyM1x1+0.07)
		Cordpassx2=cordx2
		XY=(cordx2-0.13:xy2))
		when((cordx2<ActualPolyM1x1+0.07)
		Cordpassx2=cordx2
		XY=(ActualPolyM1x1-0.06:xy2))
		dbSet(INST XY "xy"))
		when((INST->cellName=="stack.NPLUG.0")&&(xy1==0.165&&xy2==0.27)
		when((cordx1<=ActualPolyM1x2-0.07)
		XY=(cordx1+0.125:xy2))
		when((cordx1>ActualPolyM1x2-0.07)
		XY=(ActualPolyM1x2+0.055:xy2))
		dbSet(INST XY "xy"))
		))

	foreach(SHAPE CellView->shapes
		(let (bx1 bx2 by1 by2 x1 x2 x3 x4 x5 x6 x7 x8 y1 y2 y3 y4 y5 y6 y7 y8 xy1 xy2 pnts bbox orgn)
		bx1=caar(SHAPE~>bBox)
		by1=cadar(SHAPE~>bBox)
		bx2=caadr(SHAPE~>bBox)
		by2=cadadr(SHAPE~>bBox)
		xy1=car(SHAPE~>xy)
		xy2=cadr(SHAPE~>xy)
		x1=caar(SHAPE~>points)
		y1=cadar(SHAPE~>points)
		x2=caadr(SHAPE~>points)
		y2=cadadr(SHAPE~>points)
		x3=caaddr(SHAPE~>points)
		y3=car(cdaddr(SHAPE~>points))
		x4=car(cadddr(SHAPE~>points))
		y4=cadr(cadddr(SHAPE~>points))
		x5=caar(cddddr(SHAPE~>points))
		y5=cadar(cddddr(SHAPE~>points))
		x6=caadr(cddddr(SHAPE~>points))
		y6=cadadr(cddddr(SHAPE~>points))
		x7=caaddr(cddddr(SHAPE~>points))
		y7=car(cdaddr(cddddr(SHAPE~>points)))
		x8=car(cadddr(cddddr(SHAPE~>points)))
		y8=cadr(cadddr(cddddr(SHAPE~>points)))
		when((SHAPE~>layerName=="CO")&&((bx1==0.77&&by1==1.15)||(bx1==0.77&&by1==1.41))
		dbDeleteObject(SHAPE)
		dbCreateRect(CellView "M1" list(0.74:by1-0.01 cordpx1-0.07:by2+0.01))
		i = 0.77
		for(k 0 20
		dbCreateRect(CellView "CO" list(i:by1 i+0.04:by2))
		when((i+0.15)>(cordpx1-0.07)
		k=20
		i = 0.77)
		when((i+0.15)<=(cordpx1-0.07)
		k = k+1
		i = i + 0.11)))
		when((SHAPE~>layerName=="CO")&&((bx1==0.46&&by1==1.15)||(bx1==0.46&&by1==1.41))
		dbDeleteObject(SHAPE)
		dbCreateRect(CellView "M1" list(0.56:by1-0.01 cordnx1+0.07:by2+0.01))
		i = 0.5
		for(k 0 20
		dbCreateRect(CellView "CO" list(i:by1 i-0.04:by2))
		when((i-0.15)<(cordnx1+0.07)
		k=20
		i = 0.5)
		when((i-0.15)>=(cordnx1+0.07)
		k = k+1
		i = i - 0.11)))
		when((SHAPE~>layerName=="M1")&&(bx1==0.08)&&(by1==1.075)
		pnts=list(ActualPolyM1x2:y1 ActualPolyM1x2:y2 )
		dbSet(SHAPE pnts "points")) ; moves the net connecting to the a0
		when((SHAPE~>layerName=="M2")&&(bx1==0.08)&&(by1==0.295)
		pnts=list(ActualPolyM1x2:y1 ActualPolyM1x2:y2 )
		dbSet(SHAPE pnts "points")); moves the net connecting to the a0
		when((SHAPE~>layerName=="M1")&&(bx1==1.16)&&(by1==1.165)
		pnts=list(ActualPolyM1x1:y1 ActualPolyM1x1:y2 )
		dbSet(SHAPE pnts "points")); moves the net connecting to the a1
		when((SHAPE~>layerName=="M2")&&(bx1==1.16)&&(by1==0.565)
		pnts=list(ActualPolyM1x1:y1 ActualPolyM1x1:y2 )
		dbSet(SHAPE pnts "points")); moves the net connecting to the a1
		when((SHAPE~>layerName=="PO")&&((bx1==0.87&&by1==1.22)||(bx1==0.87&&by1==1.48))
		bbox=list(bx1:by1 ActualPolyM1x1:by2 )
		dbSet(SHAPE bbox "bBox")) ; moves the Poly connecting to the M1_Poly vias on the right side of the gate
		when((SHAPE~>layerName=="PO")&&((bx1==0.065&&by1==1.09)||(bx1==0.065&&by1==1.35))
		bbox=list(ActualPolyM1x2:by1 bx2:by2 )
		dbSet(SHAPE bbox "bBox")) ; moves the Poly connecting to the M1_Poly vias on the left side of the gate
		when((SHAPE~>layerName=="M1")&&(bx1==0.135)&&(by1==0.39)
		when((cordx1<=ActualPolyM1x2-0.07)
		pnts=list(x1:y1  cordx1+0.125:y2))
		when((cordx1>ActualPolyM1x2-0.07)
		pnts=list(x1:y1  ActualPolyM1x2+0.055:y2))
		dbSet(SHAPE pnts "points")) ; Moves the M1 connecting the NPLUG to GND
		when((SHAPE~>layerName=="M1")&&(bx1==0.835)&&(by1==0.39)
		when((cordx2>=ActualPolyM1x1+0.07)
		pnts=list(x1:y1  cordx2-0.13:y2 cordx2-0.13:y3))
		when((cordx2<ActualPolyM1x1+0.07)
		pnts=list(x1:y1  ActualPolyM1x1-0.06:y2 ActualPolyM1x1-0.06:y3))
		dbSet(SHAPE pnts "points")) ; Moves the M1 connecting the PPLUG to Vdd
		when((SHAPE~>layerName=="M1")&&(bx1==0.74)&&(by1==0.88)
		when((PWidth>0.21)
		pnts=list(x1:y1  cordpx1+0.03:y2 cordpx1+0.03:y3 x4:y4))
		when((PWidth<=0.21)
		pnts=list(x1:y1  x2:y2 x3:y3 x4:y4))
		dbSet(SHAPE pnts "points")) ; moves the M1 connecting the internal net of the C2_Stat on the right side of the leaf cell
		when((SHAPE~>layerName=="M1")&&(bx1==0.235)&&(by1==2.95)
		pnts=list(x1:y1 cordx1+0.07:y2 )
		dbSet(SHAPE pnts "points")) ; moves the M1 wire connecting the b net
		when((SHAPE~>layerName=="M2")&&(bx1==0.22)&&(by1==1.86)
		pnts=list(cordx1+0.07:y1 cordx1+0.07:y2 )
		dbSet(SHAPE pnts "points")) ; moves the M2 wire connecting the b input on the left side of the gate
		when((SHAPE~>layerName=="prBoundary")
		dbDeleteObject(SHAPE)
		when((cordx1<=ActualPolyM1x2-0.07)&&(cordx2>=ActualPolyM1x1+0.07)
		pnts=list(cordx1-0.04:by1 cordx1-0.04:by2 cordx2+0.04:by2 cordx2+0.04:by1))
		when((cordx1<=ActualPolyM1x2-0.07)&&(cordx2<ActualPolyM1x1+0.07)
		pnts=list(cordx1-0.04:by1 cordx1-0.04:by2 ActualPolyM1x1+0.11:by2 ActualPolyM1x1+0.11:by1))
		when((cordx1>ActualPolyM1x2-0.07)&&(cordx2>=ActualPolyM1x1+0.07)
		pnts=list(ActualPolyM1x2-0.11:by1 ActualPolyM1x2-0.11:by2 cordx2+0.04:by2 cordx2+0.04:by1))
		when((cordx1>ActualPolyM1x2-0.07)&&(cordx2<ActualPolyM1x1+0.07)
		pnts=list(ActualPolyM1x2-0.11:by1 ActualPolyM1x2-0.11:by2 ActualPolyM1x1+0.11:by2 ActualPolyM1x1+0.11:by1))
		dbCreatePRBoundary(CellView pnts)); moves the prBoundary
		when((SHAPE~>layerName=="M3")&&((bx1==0&&by1==0.025)||(bx1==0&&by1==1.465)||(bx1==0&&by1==1.585)||(bx1==0&&by1==3.025))
		when((cordx1<=ActualPolyM1x2-0.07)&&(cordx2>=ActualPolyM1x1+0.07)
		bbox=list(cordx1-0.04:by1 cordx2+0.04:by2)
		LeftLeaf=cordx1-0.04
		RightLeaf=(cordx2+0.04)-(cordx1-0.04))
		when((cordx1<=ActualPolyM1x2-0.07)&&(cordx2<ActualPolyM1x1+0.07)
		bbox=list(cordx1-0.04:by1 ActualPolyM1x1+0.11:by2)
		LeftLeaf=cordx1-0.04
		RightLeaf=(ActualPolyM1x1+0.11)-(cordx1-0.04))
		when((cordx1>ActualPolyM1x2-0.07)&&(cordx2>=ActualPolyM1x1+0.07)
		bbox=list(ActualPolyM1x2-0.11:by1 cordx2+0.04:by2)
		LeftLeaf=ActualPolyM1x2-0.11
		RightLeaf=(cordx2+0.04)-(ActualPolyM1x2-0.11))
		when((cordx1>ActualPolyM1x2-0.07)&&(cordx2<ActualPolyM1x1+0.07)
		bbox=list(ActualPolyM1x2-0.11:by1 ActualPolyM1x1+0.11:by2)
		LeftLeaf=ActualPolyM1x2-0.11
		RightLeaf=(ActualPolyM1x1+0.11)-(ActualPolyM1x2-0.11))
		dbSet(SHAPE bbox "bBox")) ; moves the M3 Vdd/GND power rails
		when((SHAPE~>layerName=="PO")&&((bx1==-0.005&&by1==0.05)||(bx1==-0.005&&by1==0.18)||(bx1==-0.005&&by1==0.83)||(bx1==-0.005&&by1==0.96)||(bx1==-0.005&&by1==1.09)||(bx1==-0.005&&by1==1.22)||(bx1==-0.005&&by1==1.35)||(bx1==-0.005&&by1==1.48)||(bx1==-0.005&&by1==1.61)||(bx1==-0.005&&by1==1.74)||(bx1==-0.005&&by1==1.87)||(bx1==-0.005&&by1==2)||(bx1==-0.005&&by1==2.13)||(bx1==-0.005&&by1==2.26)||(bx1==-0.005&&by1==2.39)||(bx1==-0.005&&by1==2.52)||(bx1==-0.005&&by1==2.65)||(bx1==-0.005&&by1==2.78)||(bx1==-0.005&&by1==2.91)||(bx1==-0.005&&by1==3.04))
		when((cordx1<=ActualPolyM1x2-0.07)&&(cordx2>=ActualPolyM1x1+0.07)
		bbox=list(cordx1-0.045:by1 cordx2+0.045:by2))
		when((cordx1<=ActualPolyM1x2-0.07)&&(cordx2<ActualPolyM1x1+0.07)
		bbox=list(cordx1-0.045:by1 ActualPolyM1x1+0.115:by2))
		when((cordx1>ActualPolyM1x2-0.07)&&(cordx2>=ActualPolyM1x1+0.07)
		bbox=list(ActualPolyM1x2-0.115:by1 cordx2+0.045:by2))
		when((cordx1>ActualPolyM1x2-0.07)&&(cordx2<ActualPolyM1x1+0.07)
		bbox=list(ActualPolyM1x2-0.115:by1 ActualPolyM1x1+0.115:by2))
		dbSet(SHAPE bbox "bBox")) ; moves all the dummy Poly grid layers
		when((SHAPE~>layerName=="PO")&&((bx1==0.245&&by1==0.31)||(bx1==0.245&&by1==0.44))
		when((cordx1<=ActualPolyM1x2-0.07)&&(cordx2>=ActualPolyM1x1+0.07)
		bbox=list(cordx1+0.205:by1 cordx2+0.045:by2))
		when((cordx1<=ActualPolyM1x2-0.07)&&(cordx2<ActualPolyM1x1+0.07)
		bbox=list(cordx1+0.205:by1 ActualPolyM1x1+0.115:by2))
		when((cordx1>ActualPolyM1x2-0.07)&&(cordx2>=ActualPolyM1x1+0.07)
		bbox=list(ActualPolyM1x2+0.135:by1 cordx2+0.045:by2))
		when((cordx1>ActualPolyM1x2-0.07)&&(cordx2<ActualPolyM1x1+0.07)
		bbox=list(ActualPolyM1x2+0.135:by1 ActualPolyM1x1+0.115:by2))
		dbSet(SHAPE bbox "bBox")) ; moves the two dummy poly grid associated with the NPLUG
		when((SHAPE~>layerName=="PO")&&((bx1==-0.005&&by1==0.57)||(bx1==-0.005&&by1==0.7))
		when((cordx1<=ActualPolyM1x2-0.07)&&(cordx2>=ActualPolyM1x1+0.07)
		bbox=list(cordx1-0.045:by1 cordx2-0.235:by2))
		when((cordx1<=ActualPolyM1x2-0.07)&&(cordx2<ActualPolyM1x1+0.07)
		bbox=list(cordx1-0.045:by1 ActualPolyM1x1-0.165:by2))
		when((cordx1>ActualPolyM1x2-0.07)&&(cordx2>=ActualPolyM1x1+0.07)
		bbox=list(ActualPolyM1x2-0.115:by1 cordx2-0.235:by2))
		when((cordx1>ActualPolyM1x2-0.07)&&(cordx2<ActualPolyM1x1+0.07)
		bbox=list(ActualPolyM1x2-0.115:by1 ActualPolyM1x1-0.165:by2))
		dbSet(SHAPE bbox "bBox")) ; moves the two dummy poly grid associated with the PPLUG
		when((SHAPE~>layerName=="PO")&&(bx1==-0.04&&by1==0)
		when((cordx1<=ActualPolyM1x2-0.07)
		bbox=list(cordx1-0.08:by1 cordx1:by2))
		when((cordx1>ActualPolyM1x2-0.07)
		bbox=list(ActualPolyM1x2-0.16:by1 ActualPolyM1x2-0.07:by2))
		dbSet(SHAPE bbox "bBox")) ; Moves the cut_Poly on the left side
		when((SHAPE~>layerName=="PO")&&(bx1==1.26&&by1==0)
		when((cordx2>=ActualPolyM1x1+0.07)
		bbox=list(cordx2:by1 cordx2+0.08:by2))
		when((cordx2<ActualPolyM1x1+0.07)
		bbox=list(ActualPolyM1x1+0.07:by1 ActualPolyM1x1+0.16:by2))
		dbSet(SHAPE bbox "bBox")) ; Moves the cut_Poly on the right side
		when((SHAPE~>layerName=="M3")&&((bx1==0.085&&by1==0.295)||(bx1==0.085&&by1==0.555)||(bx1==0.085&&by1==1.855))
		when((cordx1<=ActualPolyM1x2-0.07)&&(cordx2>=ActualPolyM1x1+0.07)
		bbox=list(cordx1:by1 cordx2:by2))
		when((cordx1<=ActualPolyM1x2-0.07)&&(cordx2<ActualPolyM1x1+0.07)
		bbox=list(cordx1:by1 ActualPolyM1x1+0.07:by2))
		when((cordx1>ActualPolyM1x2-0.07)&&(cordx2>=ActualPolyM1x1+0.07)
		bbox=list(ActualPolyM1x2-0.07:by1 cordx2:by2))
		when((cordx1>ActualPolyM1x2-0.07)&&(cordx2<ActualPolyM1x1+0.07)
		bbox=list(ActualPolyM1x2-0.07:by1 ActualPolyM1x1+0.07:by2))
		dbSet(SHAPE bbox "bBox")) ; moves all the M3 pins
		when(((SHAPE~>layerName=="NP")||(SHAPE~>layerName=="NW"))&&((bx1==0&&by1==2.99)||(bx1==0&&by2==0.13)||(bx1==0&&by1==1.585)||(bx1==0&&by1==3.025))
		when((cordx1<=ActualPolyM1x2-0.07)&&(cordx2>=ActualPolyM1x1+0.07)
		bbox=list(cordx1-0.04:by1 cordx2+0.04:by2))
		when((cordx1<=ActualPolyM1x2-0.07)&&(cordx2<ActualPolyM1x1+0.07)
		bbox=list(cordx1-0.04:by1 ActualPolyM1x1+0.11:by2))
		when((cordx1>ActualPolyM1x2-0.07)&&(cordx2>=ActualPolyM1x1+0.07)
		bbox=list(ActualPolyM1x2-0.11:by1 cordx2+0.04:by2))
		when((cordx1>ActualPolyM1x2-0.07)&&(cordx2<ActualPolyM1x1+0.07)
		bbox=list(ActualPolyM1x2-0.11:by1 ActualPolyM1x1+0.11:by2))
		dbSet(SHAPE bbox "bBox")) ; Moves the top and bottom NP/NW layers
		when((SHAPE~>layerName=="PP")&&(bx1==0&&by1==0.27)
		when((cordx1<=ActualPolyM1x2-0.07)
		bbox=list(cordx1-0.04:by1 cordx1+0.02:by2))
		when((cordx1>ActualPolyM1x2-0.07)
		bbox=list(ActualPolyM1x2-0.11:by1 ActualPolyM1x2-0.05:by2))
		dbSet(SHAPE bbox "bBox")) ; Moves the PP layer next to the NPLUG on the left side
		when((SHAPE~>layerName=="NP")&&(bx1==0&&by2==3.12)
		when((cordx1<=ActualPolyM1x2-0.07)
		pnts=list(x1:y1 cordx1-0.04:y2 cordx1-0.04:y3 cordx1+0.23:y4 cordx1+0.23:y5 cordx1-0.04:y6 cordx1-0.04:y7 x8:y8))
		when((cordx1>ActualPolyM1x2-0.07)
		pnts=list(x1:y1 ActualPolyM1x2-0.11:y2 ActualPolyM1x2-0.11:y3 ActualPolyM1x2+0.16:y4 ActualPolyM1x2+0.16:y5 ActualPolyM1x2-0.11:y6 ActualPolyM1x2-0.11:y7 x8:y8))
		dbSet(SHAPE pnts "points")) ; Moves the NP layer on the left side
		when((SHAPE~>layerName=="NP")&&(bx1==1.23&&by1==0.485)
		when((cordx2>=ActualPolyM1x1+0.07)
		bbox=list(cordx2-0.03:by1 cordx2+0.04:by2))
		when((cordx2<ActualPolyM1x1+0.07)
		bbox=list(ActualPolyM1x1+0.04:by1 ActualPolyM1x1+0.11:by2))
		dbSet(SHAPE bbox "bBox")) ; Moves the PP layer next to the PPLUG on the left side
		when(((SHAPE~>layerName=="NW")||(SHAPE~>layerName=="PM"))&&(bx1==0.65&&by1==0.13)
		when((cordx2>=ActualPolyM1x1+0.07)
		bbox=list(bx1:by1 cordx2+0.04:by2))
		when((cordx2<ActualPolyM1x1+0.07)
		bbox=list(bx1:by1 ActualPolyM1x1+0.11:by2))
		dbSet(SHAPE bbox "bBox")) ; Moves the NW/PM layer on the right side
		when((SHAPE~>layerName=="PP")&&(bx1==0.65&&by1==0.13)
		when((cordx2>=ActualPolyM1x1+0.07)
		pnts=list(cordx2+0.04:y1 cordx2-0.235:y2 cordx2-0.235:y3 cordx2+0.04:y4 cordx2+0.04:y5 x6:y6 x7:y7 cordx2+0.04:y8))
		when((cordx2<ActualPolyM1x1+0.07)
		pnts=list(ActualPolyM1x1+0.11:y1 ActualPolyM1x1-0.165:y2 ActualPolyM1x1-0.165:y3 ActualPolyM1x1+0.11:y4 ActualPolyM1x1+0.11:y5 x6:y6 x7:y7 ActualPolyM1x1+0.11:y8))
		dbSet(SHAPE pnts "points")) ; Moves the PP layer on the right side
		))
	foreach(VIA CellView->vias
		(let (vx1 vy1 bx1 by1 bx2 by2 vx1 vy1 orgn)
		bx1=caar(VIA~>bBox)
		by1=cadar(VIA~>bBox)
		bx2=caadr(VIA~>bBox)
		by2=cadadr(VIA~>bBox)
		vx1=car(VIA~>origin)
		vy1=cadr(VIA~>origin)
		when(((VIA~>viaHeader~>viaDefName=="M2_M1")||(VIA~>viaHeader~>viaDefName=="M3_M2"))&&(vx1==0.11)
		orgn=(ActualPolyM1x2:vy1)
		dbSet(VIA orgn "origin"))
		when(((VIA~>viaHeader~>viaDefName=="M2_M1")||(VIA~>viaHeader~>viaDefName=="M3_M2"))&&(vx1==1.19)
		orgn=(ActualPolyM1x1:vy1)
		dbSet(VIA orgn "origin"))
		when((VIA~>viaHeader~>viaDefName=="M2_M1")&&(vx1==0.25)
		orgn=(cordx1+0.07:vy1)
		dbSet(VIA orgn "origin"))
		))
	))
(defun CtreeCreator ( CellName ViewName )

    let( ( k l m n y s z ce  cel piecess piecesss cv ncv mcv lcv vcv TemplateCellName pieces LibName Temp LeftLeaf RightLeaf ActualPassPolyM1x1 Cordpassx2)
        pieces=parseString( CellName "." )
        LibName=nth( 0 pieces )
	k="0"
	l="0"
	m="0"
	n="0"
        for( n 1 length(pieces)-3
            LibName = strcat( LibName "." nth( n pieces )))
        cv=nrOpenCellViewReadable( LibName CellName ViewName )
        TemplateCellName = "lib.util.ctree.CTREE2.ctreetemplate"
	mcv=nrOpenCellViewReadable( LibName TemplateCellName "Template")

        when( cv != nil
            printf( "CTREE type already exists %s\n" CellName)
            )
	when( mcv == nil
	    printf("Template Cell doesnot exists %s\n" TemplateCellName))
         when( ((cv == nil)&&(mcv != nil))
            printf("yes\n")
            betterCopyCellView(mcv LibName CellName "scratch" nil nil t)
            ncv = nrOpenCellViewWritable( LibName CellName "scratch" )
	    MakeCtree2( ncv ViewName)
		dbSave(ncv)
		dbPurge(ncv)
            lcv = nrOpenCellViewWritable( LibName CellName ViewName )
		CopyBuffer( lcv ViewName LibName CellName ))
		))

(defun CopyBuffer ( CellView ViewName LibName CellName )
 		(let (xy1 xy2 XY bx1 bx2 by1 by2 buf rightcord RightCord pnts SHAPE)
		when(minusp(LeftLeaf)
		buf = dbCreateInstByMasterName(CellView LibName CellName "scratch" "buf" 0.04:0 "R0"))
		when(plusp(LeftLeaf)
		buf = dbCreateInstByMasterName(CellView LibName CellName "scratch" "buf" LeftLeaf:0 "R0"))
		when(LeftLeaf==0
		buf = dbCreateInstByMasterName(CellView LibName CellName "scratch" "buf" 0.04:0 "R0"))
		foreach(INST CellView~>instances
		xy1=car(INST~>xy)
		xy2=cadr(INST~>xy)
		bx1=caar(INST~>bBox)
		by1=cadar(INST~>bBox)
		bx2=caadr(INST~>bBox)
		by2=cadadr(INST~>bBox)
		XY=(-bx1:xy2)
		dbSet(INST XY "xy"))
		dbFlattenInst(buf 1)
		rightcord=round(((RightLeaf/0.26)/0.5)*0.5+0.5)
		RightCord=0.26*rightcord
		pnts=list(0:by1+0.13 0:by2-0.13 RightCord:by2-0.13 RightCord:by1+0.13)
		dbCreatePRBoundary(CellView pnts)
	foreach(INST CellView->instances
		(let (xy1 xy2 XY bx1 bx2 by1 by2)
		xy1=car(INST~>xy)
		xy2=cadr(INST~>xy)
		bx1=caar(INST~>bBox)
		by1=cadar(INST~>bBox)
		bx2=caadr(INST~>bBox)
		by2=cadadr(INST~>bBox)
		when((INST->cellName=="stack.PPLUG.0")
		XY=(RightCord-0.17:xy2)
		dbSet(INST XY "xy"))
		))
	foreach(SHAPE CellView->shapes
		(let (bx1 bx2 by1 by2 x1 x2 x3 x4 x5 x6 x7 x8 y1 y2 y3 y4 y5 y6 y7 y8 xy1 xy2 pnts bbox orgn)
		bx1=caar(SHAPE~>bBox)
		by1=cadar(SHAPE~>bBox)
		bx2=caadr(SHAPE~>bBox)
		by2=cadadr(SHAPE~>bBox)
		xy1=car(SHAPE~>xy)
		xy2=cadr(SHAPE~>xy)
		x1=caar(SHAPE~>points)
		y1=cadar(SHAPE~>points)
		x2=caadr(SHAPE~>points)
		y2=cadadr(SHAPE~>points)
		x3=caaddr(SHAPE~>points)
		y3=car(cdaddr(SHAPE~>points))
		x4=car(cadddr(SHAPE~>points))
		y4=cadr(cadddr(SHAPE~>points))
		x5=caar(cddddr(SHAPE~>points))
		y5=cadar(cddddr(SHAPE~>points))
		x6=caadr(cddddr(SHAPE~>points))
		y6=cadadr(cddddr(SHAPE~>points))
		x7=caaddr(cddddr(SHAPE~>points))
		y7=car(cdaddr(cddddr(SHAPE~>points)))
		x8=car(cadddr(cddddr(SHAPE~>points)))
		y8=cadr(cadddr(cddddr(SHAPE~>points)))
		when(((SHAPE~>layerName=="NW")||(SHAPE~>layerName=="NP"))&&((by2==3.25&&by1==2.99)||(by2==0.13&&by1==-0.13))
		bbox=list(0:by1 RightCord:by2)
		dbSet(SHAPE bbox "bBox")) ; moves the NW/NP layers on top and bottom
		when(((SHAPE~>layerName=="NW")||(SHAPE~>layerName=="PM"))&&by2==2.99&&by1==0.13
		bbox=list(bx1:by1 RightCord:by2)
		dbSet(SHAPE bbox "bBox")) ; moves the NW/PM layer on the right side of the leaf cell
		when((SHAPE~>layerName=="PP")&&by2==2.99&&by1==0.13
		pnts=list(RightCord:y1 RightCord-0.275:y2 RightCord-0.275:y3 RightCord:y4 RightCord:y5 x6:y6 x7:y7 RightCord:y8)
		dbSet(SHAPE pnts "points")) ; moves the PP layer on the right side of the leaf cell
		when((SHAPE~>layerName=="NP")&&by2==1.01&&by1==0.485
		bbox=list(RightCord-0.07:by1 RightCord:by2)
		dbSet(SHAPE bbox "bBox")) ; moves the NP layer on the right side of the leaf cell associated with PPLUG
		when((SHAPE~>layerName=="M3")&&((by2==0.095&&by1==0.025)||(by2==1.535&&by1==1.465)||(by2==1.655&&by1==1.585)||(by2==3.095&&by1==3.025))
		bbox=list(0:by1 RightCord:by2)
		dbSet(SHAPE bbox "bBox")) ;moves the M3 power grid(GND/Vdd) wires
		when((SHAPE~>layerName=="M3")&&((by2==0.355&&by1==0.295)||(by2==0.615&&by1==0.555)||(by2==1.915&&by1==1.855))
		bbox=list(0.04:by1 RightCord-0.04:by2)
		dbSet(SHAPE bbox "bBox")) ;moves the M3 _RESET pin
		when((SHAPE~>layerName=="M1")&&by2==0.69&&by1==0.39
		pnts=list(x1:y1 RightCord-0.17:y2 RightCord-0.17:y3)
		dbSet(SHAPE pnts "points")) ; moves the M1 connecting the PPLUG to Vdd
		))
		DeleteGridPoly(?CellView CellView)
		DrawGridPoly(?CellView CellView)
		ddDeleteObj(ddGetObj(LibName CellName "scratch"))
		dbSave(CellView)
		dbPurge(CellView)
 )
)

(defun Parameter ( CellName)
	(let (fl pieces piece specname initialpath InitialPath IntermediatePath finalpath k text Variable1 cst FinalPath variable1 variable2 variable3 variable4 Variable3 Variable4 var3 var4 Var3 varb4 Varb3 Var4 Outfl)
	println(CellName)
	pieces=parseString( CellName "." )
	specname=nth( 4 pieces )
	cst=".cast"
	IntermediatePath="/lib/util/ctree/CTREE2/"
	initialpath=ConfigFileGetValue(TheCDSConfigTable "CAST_PATH")
	piece=parseString( initialpath ":" )
	InitialPath=nth( 1 piece )
	finalpath=strcat(InitialPath IntermediatePath specname cst)
	fl = infile(finalpath)
	Outfl = outfile("Parameter.txt" "w")
	while( gets(k fl) != nil
  	text = parseString( k " \n")
	Variable1 = nth(0 text)
	when((Variable1=="Xx")
	variable1=car(parseString( Variable1 "X" ))
	variable2=nth(6 text)
	Variable3=nth(7 text)
	Var3=parseString( Variable3 "=" )
	Varb3=nth( 1 Var3)
	var3=parseString( Varb3 "u" )
	variable3=nth( 0 var3)
	Variable4=nth(8 text)
	Var4=parseString( Variable4 "=" )
	Varb4=nth( 1 Var4)
	var4=parseString( Varb4 "u" )
	variable4=nth( 0 var4)
	fprintf(Outfl "%s" variable1 )
	fprintf(Outfl " %s" variable2 )
	fprintf(Outfl " %s" variable3 )
	fprintf(Outfl " %s\n" variable4 )
	)
	when((Variable1=="Xb")
	variable1=car(parseString( Variable1 "X" ))
	variable2=nth(8 text)
	Variable3=nth(9 text)
	Var3=parseString( Variable3 "=" )
	Varb3=nth( 1 Var3)
	var3=parseString( Varb3 "u" )
	variable3=nth( 0 var3)
	Variable4=nth(10 text)
	Var4=parseString( Variable4 "=" )
	Varb4=nth( 1 Var4)
	var4=parseString( Varb4 "u" )
	variable4=nth( 0 var4)
	fprintf(Outfl "%s" variable1 )
	fprintf(Outfl " %s" variable2 )
	fprintf(Outfl " %s" variable3 )
	fprintf(Outfl " %s\n" variable4 )
	)
)
	close(Outfl)
	close(fl)
	))
(defun Ctree ( CellName)
	printf("Cell is %s\n" CellName)
	Parameter(CellName)
  	CtreeCreator(CellName "layout")
)

(defun Draw_V0TPX (xy @key (CV (geGetEditCellView)))
  (let (viaDef ax ay x y)
    viaDef = (techFindViaDefByName (techGetTechFile CV) "via0TPX")
    x = (car xy)
    y = (cadr xy)
    ax = (x + 0.021)
    ay = (y + 0.021)
    (dbCreateVia CV viaDef ax:ay "R0")
  )
)
; Dont use the TAX vias as they dont exist in the tech file
; Even for V0_24 and V0_25 errors use the V0TPX vias
(defun Draw_V0TAX (xy @key (CV (geGetEditCellView)))
  (let (viaDef ax ay x y)
    viaDef = (techFindViaDefByName (techGetTechFile CV) "v0TAX")
    viaDef = (techFindViaVariantByName techFile "v0TAX")
    x = (car xy)
    y = (cadr xy)
    ax = (x + 0.021)
    ay = (y + 0.021)
    (dbCreateVia CV viaDef ax:ay "R0")
  )
)

; Copyright (c) 2025 Intel Corporation.  All rights reserved.  See the file COPYRIGHT for more information.
; SPDX-License-Identifier: Apache-2.0

(defun MakeBuffer (CellView ViewName)
	(let (text parameter1 parameter2 parameter3 parameter4 cordM2_M1 INST SHAPE Inst_Reset cordpx1 cordpx2 cordnx1 cordnx2 cordnrx1 cordnrx2 cordRRx cordRaRx cordR2Rx cordR2Lx cordLeRx cordResRx cordUResRx cordPLx cordPLx1 cordPLx2 ixy1 ixy2 diffpass centreXY cordPCLx DIFF Lpinx foldss)
	fl = infile("Parameter.txt")
	while( gets(k fl) != nil
  	text = parseString( k " \n")
	parameter1 = nth(0 text)
	parameter2 = nth(1 text)
	parameter3 = nth(2 text)
	parameter4 = nth(3 text)

 ;setting instance parameters as per the spec file
	foreach(INST CellView->instances
		(let (N P Nparam Pparam paraN1 paraN2 paraP1 paraP2 paraP3 paraP4 paraP5 paraP6 paraP7 paraP8 paraP9 paraP10)
		when( (INST->name==parameter1) && (INST->cellName=="gate.INV.0-L1_1-R")
		N=evalstring(parameter3)
		Nparam=N/1000000
		P=evalstring(parameter4)
		Pparam=P/1000000
		dbReplaceProp(INST "NW1" "float" Nparam)
		dbReplaceProp(INST "PW1" "float" Pparam)
		)
		when( ( (INST->cellName=="stack.NMOS_CHAIN_2.0-L1-R") || (INST->cellName=="stack.NMOS_CHAIN_5.0-L1-R") || (INST->cellName=="stack.PMOS_CHAIN_2.0-L1-R") || (INST->cellName=="stack.PMOS_CHAIN_1.0-L1-R"))
		paraN1 = strcat( parameter1 "." "N1")
		paraN2 = strcat( parameter1 "." "N2")
		paraP1 = strcat( parameter1 "." "P1")
		paraP2 = strcat( parameter1 "." "P2")
		paraP3 = strcat( parameter1 "." "P3")
		paraP4 = strcat( parameter1 "." "P4")
		paraP5 = strcat( parameter1 "." "P5")
		paraP6 = strcat( parameter1 "." "P6")
		paraP7 = strcat( parameter1 "." "P7")
		paraP8 = strcat( parameter1 "." "P8")
		paraP9 = strcat( parameter1 "." "P9")
		paraP10 = strcat( parameter1 "." "P10")
		when(((INST->name==paraN1) || (INST->name==paraP1) || (INST->name==paraN2) || (INST->name==paraP2) || (INST->name==paraP3) || (INST->name==paraP4) || (INST->name==paraP5) || (INST->name==paraP6) || (INST->name==paraP7) || (INST->name==paraP8) || (INST->name==paraP9) || (INST->name==paraP10))
		N=evalstring(parameter3)
		Nparam=N/2000000
		P=evalstring(parameter4)
		Pparam=P/2000000
		dbReplaceProp(INST "NW2" "float" Nparam)
		dbReplaceProp(INST "NW5" "float" Nparam)
		dbReplaceProp(INST "PW2" "float" Pparam)
		dbReplaceProp(INST "PW1" "float" Pparam)
		))
		)))
	foreach(INST CellView->instances
		(let (cordNx cordNx1 cordNx2 cordPx cordPx1 cordPx2 xy1 xy2 XY bx1 bx2 by1 by2 diff)
		xy1=car(INST~>xy)
		xy2=cadr(INST~>xy)
		bx1=caar(INST~>bBox)
		by1=cadar(INST~>bBox)
		bx2=caadr(INST~>bBox)
		by2=cadadr(INST~>bBox)
		when(((INST->cellName=="stack.NMOS_CHAIN_2.0-L1-R") && (INST->name=="_r.2.N1"))
			cordNx=caar(INST~>bBox)
			cordNx1=cordNx+0.02
			cordnx1=cordNx1
			cordNx2=cordNx1-0.06
			cordnx2=cordNx2)
		when(((INST->cellName=="stack.PMOS_CHAIN_2.0-L1-R") && (INST->name=="_r.2.P1"))
			cordPx=caadr(INST~>bBox)
			Lpinx=caar(INST~>bBox)
			cordPx1=cordPx-0.02
			cordpx1=cordPx1
			cordPx2=cordPx1+0.06
			cordpx2=cordPx2)
		))

;calculating variables for moving wires, vias and instances

	foreach(INST CellView->instances
		(let (cordNRx cordNRx1 cordNRx2 xy1 xy2 XY bx1 bx2 by1 by2 diff)
		xy1=car(INST~>xy)
		xy2=cadr(INST~>xy)
		bx1=caar(INST~>bBox)
		by1=cadar(INST~>bBox)
		bx2=caadr(INST~>bBox)
		by2=cadadr(INST~>bBox)
		when((INST->cellName=="gate.INV.0-L1_1-R") && ((INST->name=="R.3")||(INST->name=="R.1"))
		diff=xy1-bx1
		XY=((cordpx2+0.25+diff):xy2)
		dbSet(INST XY "xy")
		ixy1=car(INST~>xy)
		ixy2=cadr(INST~>xy))
	))

	foreach(INST CellView~>instances
		(let (xy1 xy2 XY bx1 bx2 by1 by2 pnts bbox diff)
		xy1=car(INST~>xy)
		xy2=cadr(INST~>xy)
		bx1=caar(INST~>bBox)
		by1=cadar(INST~>bBox)
		bx2=caadr(INST~>bBox)
		by2=cadadr(INST~>bBox)
		when((INST~>cellName=="M1_POLYmin")&&(((xy2==5.915)&&(xy1==1.3))||((xy2==5.655)&&(xy1==1.3))||((xy2==1.495)&&(xy1==1.295))||((xy2==1.235)&&(xy1==1.295)))
		XY=(cordpx2+0.1:xy2)
		dbSet(INST XY "xy")) ;moves M1_poly vias on the right side of C2 gates in 1st coloumn
		when((INST~>cellName=="M2_M1_2cut_p1_2")&&((bx1==1.51)&&(bx2==1.72))
		XY=(ixy1-0.195:xy2)
		dbSet(INST XY "xy"))
		when((INST~>cellName=="M2_M1_2cut_p1_2")&&((bx1==1.9)&&(bx2==2.11))
		XY=(ixy1+0.195:xy2)
		dbSet(INST XY "xy"))
		when((INST->cellName=="gate.INV.0-L1_1-R") && ((INST->name=="R.2")||(INST->name=="R.0"))
		dbReplaceProp(INST "n_contact_offset" "float" (cordnx2+0.025)))
		when(((INST->cellName=="stack.PMOS_CHAIN_1.0-L1-R")||(INST->cellName=="stack.PMOS_CHAIN_2.0-L1-R")) && ((INST->name=="RP.3")||(INST->name=="RP.1")||(INST->name=="_r.3.P2")||(INST->name=="_r.1.P1")||(INST->name=="_r.3.P1")||(INST->name=="_r.1.P2"))
		XY=((ixy1-0.01):xy2)
		dbSet(INST XY "xy"))
		when(((INST->cellName=="stack.NMOS_CHAIN_1.0-L1-R")||(INST->cellName=="stack.NMOS_CHAIN_2.0-L1-R")) && ((INST->name=="RN.3")||(INST->name=="RN.1")||(INST->name=="_r.3.N2")||(INST->name=="_r.1.N1")||(INST->name=="_r.3.N1")||(INST->name=="_r.1.N2"))
		XY=((ixy1+0.01):xy2)
		dbSet(INST XY "xy"))
		when((INST->cellName=="gate.INV.0-L1_1-R")&&(INST->name=="R.3")
			cordRRx=caadr(INST~>bBox))

		))

	foreach(INST CellView->instances
		(let (cordNRx cordNRx1 cordNRx2 xy1 xy2 XY bx1 bx2 by1 by2 diff cordplx)
		xy1=car(INST~>xy)
		xy2=cadr(INST~>xy)
		bx1=caar(INST~>bBox)
		by1=cadar(INST~>bBox)
		bx2=caadr(INST~>bBox)
		by2=cadadr(INST~>bBox)
		when((INST->cellName=="stack.NMOS_CHAIN_2.0-L1-R")&&(INST->name=="_r.3.N1")
			cordNRx=caadr(INST~>bBox)
			cordNRx1=cordNRx-0.02
			cordnrx1=cordNRx1
			cordNRx2=cordNRx1+0.06
			cordnrx2=cordNRx2)
		when((INST->cellName=="stack.PMOS_CHAIN_2.0-L1-R")&&(INST->name=="_r.3.P1")
			cordPLx=caadr(INST~>bBox)
			cordplx=caar(INST~>bBox)
			cordPLx1=cordplx+0.02
			cordPLx2=cordPLx1-0.06)
		when((INST->cellName=="gate.INV.0-L1_1-R")&&(INST->name=="R.2")
			cordR2Lx=caar(INST~>bBox)
			cordR2Rx=caadr(INST~>bBox))
		when((INST->cellName=="gate.INV.0-L1_1-R")&&(INST->name=="L.e")
			foldss=cadadr(INST~>bBox)
			cordLeRx=caadr(INST~>bBox))
		when((INST->cellName=="gate.INV.0-L1_1-R")&&(INST->name=="Reset")
			cordResRx=caar(INST~>bBox))
		when((INST->cellName=="gate.INV.0-L1_1-R")&&(INST->name=="_Reset")
			cordUResRx=caadr(INST~>bBox))
		when((INST->cellName=="gate.INV.0-L1_1-R")&&((INST->name=="R.3")||(INST->name=="R.1"))
		when((ixy1+0.36)>=(cordRRx-0.255)
		dbReplaceProp(INST "n_contact_offset" "float" (ixy1+0.36-cordRRx+0.255)))
		when((ixy1+0.36)<(cordRRx-0.255)
		dbReplaceProp(INST "n_contact_offset" "float" 0.065)))

	))

	foreach(INST CellView~>instances
		(let (xy1 xy2 XY bx1 bx2 by1 by2 pnts bbox diff)
		xy1=car(INST~>xy)
		xy2=cadr(INST~>xy)
		bx1=caar(INST~>bBox)
		by1=cadar(INST~>bBox)
		bx2=caadr(INST~>bBox)
		by2=cadadr(INST~>bBox)
		when((INST~>cellName=="M1_POLYmin")&&(((xy2==5.785)&&(xy1==0.115))||((xy2==5.525)&&(xy1==0.115))||((xy2==5.265)&&(xy1==0.11))||((xy2==1.365)&&(xy1==0.115))||((xy2==1.105)&&(xy1==0.115))||((xy2==0.845)&&(xy1==0.11)))
		when(cordR2Lx>=cordnx2
		XY=(cordnx2-0.1:xy2))
		when(cordR2Lx<cordnx2
		XY=(cordR2Lx-0.05:xy2))
		dbSet(INST XY "xy")) ;moves M1_poly vias on the left side of the C2 gates in 1st coloumn
		when((INST~>cellName=="M1_POLYmin")&&(((xy2==5.005)&&(xy1==1.15))||((xy2==4.745)&&(xy1==1.15))||((xy2==0.585)&&(xy1==1.145))||((xy2==0.325)&&(xy1==1.145)))
		XY=(cordR2Rx+0.15:xy2)
		dbSet(INST XY "xy")) ;moves M1_poly vias on the left side of the C2 gates in 2nd coloumn
		when((INST->cellName=="gate.INV.0-L1_1-R")&&(INST->name=="R.3")
			cordRaRx=caadr(INST~>bBox))
		when((INST->cellName=="stack.NPLUG.0")&&(xy1==2.44&&xy2==2.335)
		when(cordRaRx>=(cordnrx2+0.03)
		XY=((cordRaRx+0.025):xy2))
		when(cordRaRx<(cordnrx2+0.03)
		XY=((cordnrx2+0.05):xy2))
		dbSet(INST XY "xy"));moves NPLUG on right side
		when((INST->cellName=="stack.NPLUG.0")&&(xy1==0.13&&xy2==3.38)
		when(cordR2Lx>=cordnx2
		XY=((cordnx2-0.08):xy2))
		when(cordR2Lx<cordnx2
		XY=(cordR2Lx-0.03:xy2))
		dbSet(INST XY "xy"));moves NPLUG on left side
		when((INST->cellName=="stack.PPLUG.0")&&(xy1==1.64&&xy2==1.785)
		XY=((ixy1-0.17):xy2)
		dbSet(INST XY "xy"))
		when((INST->cellName=="stack.NMOS_CHAIN_5.0-L1-R")&&((INST->name=="rv.N2")||(INST->name=="rv.N1"))
		diff=mag((bx2-bx1)-(cordnrx2-0.04))
		diffpass=diff
		XY=(diff:xy2)
		dbSet(INST XY "xy"))
		when((INST->cellName=="gate.INV.0-L1_1-R")&&(INST->name=="L.e")
		when(foldss==3.08
		pnts=(0.44:2.86)
		        dbCreateParamInstByMasterName(CellView "tsmc28" "M2_M1_2cut_p1_2" "layout" nil pnts "R0" 1
	               list( list("column" "int" 1)
                     list("row" "int" 1)
                     list("layer1YEnclosure" "float" 0.005)
                     list("layer1XEnclosure" "float" 0.04)
                     list("layer2YEnclosure" "float" 0.03)
                     list("layer2XEnclosure" "float" 0.015) ) ))
		when(foldss==2.95
		pnts=(0.44:2.86)
		        dbCreateParamInstByMasterName(CellView "tsmc28" "M2_M1_2cut_p1_2" "layout" nil pnts "R0" 1
	               list( list("column" "int" 1)
                     list("row" "int" 1)
                     list("layer1YEnclosure" "float" 0.005)
                     list("layer1XEnclosure" "float" 0.04)
                     list("layer2YEnclosure" "float" 0.03)
                     list("layer2XEnclosure" "float" 0.015) ) )))
		when((INST~>cellName=="M2_M1_2cut_p1_2")&&((foldss==2.56)||(foldss==2.3))&&((xy1==0.44&&xy2==2.6)||(xy1==0.83&&xy2==2.6))
		dbDeleteObject(INST))
		))

	foreach(INST CellView~>instances
		(let (xy1 xy2 XY bx1 bx2 by1 by2 pnts bbox diff)
		xy1=car(INST~>xy)
		xy2=cadr(INST~>xy)
		bx1=caar(INST~>bBox)
		by1=cadar(INST~>bBox)
		bx2=caadr(INST~>bBox)
		by2=cadadr(INST~>bBox)
		when((INST~>cellName=="M1_POLYmin")&&(((xy2==5.135)&&(xy1==2.33))||((xy2==4.875)&&(xy1==2.33))||((xy2==5.395)&&(xy1==2.33))||((xy2==0.975)&&(xy1==2.355))||((xy2==0.715)&&(xy1==2.335))||((xy2==0.455)&&(xy1==2.335)))
		when(cordRaRx>=(cordnrx2+0.03)
		XY=(cordRaRx+0.075:xy2))
		when(cordRaRx<(cordnrx2+0.03)
		XY=(cordnrx2+0.1:xy2))
		dbSet(INST XY "xy")) ;moves M1_poly vias on the right side of the C2 gates in 2nd coloumn

		when((INST->cellName=="stack.PMOS_CHAIN_1.0-L1-R")&&((INST->name=="rv.P1")||(INST->name=="rv.P2")||(INST->name=="rv.P3")||(INST->name=="rv.P4")||(INST->name=="rv.P5")||(INST->name=="rv.P6")||(INST->name=="rv.P7")||(INST->name=="rv.P8")||(INST->name=="rv.P9")||(INST->name=="rv.P10"))
		XY=((diffpass-0.02):xy2)
		centreXY=diffpass-0.02
		diff=bx2-bx1
		cordPCLx=centreXY-diff
		dbSet(INST XY "xy"))

		))

	foreach(SHAPE CellView->shapes
		(let (bx1 bx2 by1 by2 x1 x2 x3 x4 x5 x6 x7 x8 y1 y2 y3 y4 y5 y6 y7 y8 xy1 xy2 pnts bbox orgn)
		bx1=caar(SHAPE~>bBox)
		by1=cadar(SHAPE~>bBox)
		bx2=caadr(SHAPE~>bBox)
		by2=cadadr(SHAPE~>bBox)
		xy1=car(SHAPE~>xy)
		xy2=cadr(SHAPE~>xy)
		x1=caar(SHAPE~>points)
		y1=cadar(SHAPE~>points)
		x2=caadr(SHAPE~>points)
		y2=cadadr(SHAPE~>points)
		x3=caaddr(SHAPE~>points)
		y3=car(cdaddr(SHAPE~>points))
		x4=car(cadddr(SHAPE~>points))
		y4=cadr(cadddr(SHAPE~>points))
		x5=caar(cddddr(SHAPE~>points))
		y5=cadar(cddddr(SHAPE~>points))
		x6=caadr(cddddr(SHAPE~>points))
		y6=cadadr(cddddr(SHAPE~>points))
		x7=caaddr(cddddr(SHAPE~>points))
		y7=car(cdaddr(cddddr(SHAPE~>points)))
		x8=car(cadddr(cddddr(SHAPE~>points)))
		y8=cadr(cadddr(cddddr(SHAPE~>points)))
		when((((bx2==0.545)&&(by2==5.62))||((bx2==0.53)&&(by2==1.2)))&&(SHAPE~>layerName=="M1")
		pnts=list(x1:y1 cordnx1:y2 cordnx1:y3 x4:y4 x5:y5 cordnx2:y6 cordnx2:y7 x8:y8)
		dbSet(SHAPE pnts "points")) ;to move M1 of C2 van berkel gate connecting internal nets on the left side of _r.2 and _r.0
		when((((bx1==1.9)&&(by1==5.04))||((bx1==1.9)&&(by1==0.62)))&&(SHAPE~>layerName=="M1")
		pnts=list(cordnrx2:y1 (ixy1+0.09):y2 (ixy1+0.09):y3 cordnrx1:y4 cordnrx1:y5 (ixy1+0.09):y6 (ixy1+0.09):y7 cordnrx2:y8)
		dbSet(SHAPE pnts "points")) ; to move M1 of C2 van berkel gate connecting internal nets on the right side of _r.3 and _r.1
		when((((bx1==2.005)&&(by1==5.045))||((bx1==2.005)&&(by1==0.625))||((bx1==2.005)&&(by1==4.785))||((bx1==2.005)&&(by1==0.365)))&&(SHAPE~>layerName=="OD")
		bbox=list((ixy1+0.1):by1 (ixy1+0.17):by2)
		dbSet(SHAPE bbox "bBox")) ; to move OD of C2 van berkel gate connecting internal nets on the right side of _r.3 and _r.1
		when((((bx1==2.025)&&(by1==5.05))||((bx1==2.025)&&(by1==0.63))||((bx1==2.025)&&(by1==4.79))||((bx1==2.025)&&(by1==0.37)))&&(SHAPE~>layerName=="CO")
		bbox=list((ixy1+0.12):by1 (ixy1+0.16):by2)
		dbSet(SHAPE bbox "bBox")) ; to move CO of C2 van berkel gate connecting internal nets on the right side of _r.3 and _r.1
		when((SHAPE~>layerName=="M2") && ((SHAPE~>net~>name=="L.2")||(SHAPE~>net~>name=="L.0"))
		when(cordR2Lx>=cordnx2
		pnts=list((cordnx2-0.1):by1 (cordnx2-0.1):by2))
		when(cordR2Lx<cordnx2
		pnts=list((cordR2Lx-0.05):by1 (cordR2Lx-0.05):by2))
		dbSet(SHAPE pnts "points"))
		when((SHAPE~>layerName=="M2") && ((SHAPE~>net~>name=="R.3")||(SHAPE~>net~>name=="L.1"))&&(x1==2.325)
		when(cordRaRx>=(cordnrx2+0.03)
		pnts=list((cordRaRx+0.075):by1 (cordRaRx+0.075):by2))
		when(cordRaRx<(cordnrx2+0.03)
		pnts=list((cordnrx2+0.1):by1 (cordnrx2+0.1):by2))
		dbSet(SHAPE pnts "points"))
		when((SHAPE~>layerName=="M2") && (SHAPE~>net~>name=="L.1")&&(x1==1.425)
		pnts=list((ixy1-0.385):by1 (ixy1-0.385):by2)
		dbSet(SHAPE pnts "points"))
		when((SHAPE~>layerName=="M2") && ((SHAPE~>net~>name=="_r.2")||(SHAPE~>net~>name=="_r.0"))
		when(cordR2Lx>=cordnx2
		pnts=list((cordnx2+0.04):by1 (cordnx2+0.04):by2))
		when(cordR2Lx<cordnx2
		pnts=list((cordR2Lx+0.08):by1 (cordR2Lx+0.08):by2))
		dbSet(SHAPE pnts "points"))
		when((SHAPE~>layerName=="M2") && ((SHAPE~>net~>name=="_r.3")||(SHAPE~>net~>name=="_r.1"))
		pnts=list((cordRaRx-0.06):by1 (cordRaRx-0.06):by2)
		dbSet(SHAPE pnts "points"))
		when((SHAPE~>layerName=="M1") && ((SHAPE~>net~>name=="L.2")||(SHAPE~>net~>name=="L.0"))
		when(cordR2Lx>=cordnx2
		bbox=list((cordnx2-0.13):by1 (cordnx2-0.07):by2))
		when(cordR2Lx<cordnx2
		bbox=list((cordR2Lx-0.08):by1 (cordR2Lx-0.02):by2))
		dbSet(SHAPE bbox "bBox"))
		when((SHAPE~>layerName=="PO")&&(((bx2==0.35)&&(by2==5.8))||((bx2==0.35)&&(by2==5.54))||((bx2==0.89)&&(by2==5.28))||((bx2==0.35)&&(by2==1.38))||((bx2==0.35)&&(by2==1.12))||((bx2==0.89)&&(by2==0.86)))
		when(cordR2Lx>=cordnx2
		bbox=list((cordnx2-0.1):by1 bx2:by2))
		when(cordR2Lx<cordnx2
		bbox=list((cordR2Lx-0.05):by1 bx2:by2))
		dbSet(SHAPE bbox "bBox")); moves poly on the left side of c2 gates L.2 and L.0
		when((SHAPE~>layerName=="PO")&&(((bx1==1.055)&&(by1==5.9))||((bx1==1.055)&&(by1==5.64))||((bx1==1.055)&&(by1==1.48))||((bx1==1.055)&&(by1==1.22)))
		bbox=list(bx1:by1 (cordpx2+0.1):by2)
		dbSet(SHAPE bbox "bBox")); moves poly on the right side of c2 gates R.e in 1st coloumn of gates
		when((SHAPE~>layerName=="PO")&&(((bx1==1.67)&&(by1==5.12))||((bx1==1.68)&&(by1==4.86))||((bx1==1.63)&&(by1==0.7))||((bx1==1.695)&&(by1==0.44))||((bx1==1.54)&&(by1==0.96))||((bx1==1.54)&&(by1==5.38)))
		bbox=list((ixy1-0.26):by1 (cordRaRx+0.075):by2)
		dbSet(SHAPE bbox "bBox")); moves poly on the right side of c2 gates R.e and L.1 in 2nd coloumn of gates
		when((SHAPE~>layerName=="M1")&& (SHAPE~>net~>name=="R.2")
		when(cordR2Lx>=cordnx2
		pnts=list((cordnx2-0.11):y1 (cordnx2-0.11):y2 x3:y3))
		when(cordR2Lx<cordnx2
		pnts=list((cordR2Lx-0.06):y1 (cordR2Lx-0.06):y2 x3:y3))
		dbSet(SHAPE pnts "points"))
		when((SHAPE~>layerName=="M1")&&(SHAPE~>net~>name=="R.0")&&(by2==0.875)
		when(cordR2Lx>=cordnx2
		pnts=list((cordnx2-0.11):y1 (cordnx2-0.11):y2 x3:y3))
		when(cordR2Lx<cordnx2
		pnts=list((cordR2Lx-0.06):y1 (cordR2Lx-0.06):y2 x3:y3))
		dbSet(SHAPE pnts "points"))
		when((((by1==4.975)&&(by2==5.1))||((by1==0.59)&&(by2==0.68)))&&(SHAPE~>layerName=="M1")
		when(cordR2Lx>=cordnx2
		bbox=list((cordnx2-0.015):by1 (cordnx2+0.065):by2))
		when(cordR2Lx<cordnx2
		bbox=list((cordR2Lx+0.03):by1 (cordR2Lx+0.11):by2))
		dbSet(SHAPE bbox "bBox")) ;to move M1 between poly vias and M2_M1 via in _r.2 and _r.0
		when((SHAPE~>layerName=="M1") && ((SHAPE~>net~>name=="_r.2")||(SHAPE~>net~>name=="_r.0"))&&(((bx2==0.87)&&(by2==5.75))||((bx1==0.22)&&(by1==1.27)))
		when(cordR2Lx>=cordnx2
		bbox=list((cordnx2+0.01):by1 bx2:by2))
		when(cordR2Lx<cordnx2
		bbox=list((cordR2Lx+0.05):by1 bx2:by2))
		dbSet(SHAPE bbox "bBox"))
		when((SHAPE~>layerName=="M1") && (SHAPE~>net~>name=="R.e")&&(((by1==5.625)&&(by2==5.945))||((by1==1.205)&&(by2==1.725)))
		bbox=list((cordpx2+0.07):by1 (cordpx2+0.13):by2)
		dbSet(SHAPE bbox "bBox")) ;moves M1 of R.e on the right side of the 1st coloumn of gates
		when((SHAPE~>layerName=="M1") && ((SHAPE~>net~>name=="R.e")||(SHAPE~>net~>name=="L.1")||(SHAPE~>net~>name=="_r.3"))&&(((by1==4.845)&&(by2==5.165))||((by1==0.425)&&(by2==0.745))||((by1==3.62)&&(by2==4.445)))
		when(cordRaRx>=(cordnrx2+0.03)
		bbox=list((cordRaRx+0.045):by1 (cordRaRx+0.105):by2))
		when(cordRaRx<(cordnrx2+0.03)
		bbox=list((cordnrx2+0.07):by1 (cordnrx2+0.13):by2))
		dbSet(SHAPE bbox "bBox")) ;moves M1 of R.e and L.1 on the right side of the 2nd coloumn of gates
		when((SHAPE~>layerName=="M2") && (SHAPE~>net~>name=="Vdd")&&((bx1==1.535)&&(bx2==1.695))
		bbox=list((ixy1-0.275):by1 (ixy1-0.115):by2)
		dbSet(SHAPE bbox "bBox"))
		when((SHAPE~>layerName=="M2") && (SHAPE~>net~>name=="GND")&&((bx1==1.925)&&(bx2==2.085))
		bbox=list((ixy1+0.115):by1 (ixy1+0.275):by2)
		dbSet(SHAPE bbox "bBox"))
		when((SHAPE~>layerName=="M2") &&((bx1==1.78)&&(bx2==1.84))
		pnts=list(ixy1:by1 ixy1:by2)
		dbSet(SHAPE pnts "points")) ;moves M2 in the centre of the gates of 2nd coloumn connecting internal nets and rv net
		when((SHAPE~>layerName=="M1") &&((bx1==0.84)&&(bx2==1.565))
		pnts=list(x1:y1 (cordLeRx-0.28):y2 (cordLeRx-0.28):y3 (cordPCLx+0.11):y4 (cordPCLx+0.11):y5 (diffpass-0.1):y6)
		dbSet(SHAPE pnts "points")) ;moves M1 connecting the Vdd between L.e and rv.P1
		when((SHAPE~>layerName=="M1") &&((bx1==1.33)&&(by1==2.635))
		bbox=list((cordLeRx-0.11):by1 ixy1:by2)
		dbSet(SHAPE bbox "bBox")) ;moves M1 connecting rv input of L.e gate with the rv on M2 of NAND5
		when((SHAPE~>layerName=="M1") &&(((bx1==1.125)&&(by1==4.715))||((bx1==1.115)&&(by1==0.11)))
		bbox=list((cordR2Rx+0.12):by1 (cordR2Rx+0.18):by2)
		dbSet(SHAPE bbox "bBox")) ;moves M1 of L.3 on the left side of C.2 gate in 2nd coloumn
		when((SHAPE~>layerName=="M2") &&((bx1==1.125)&&(by1==4.495))
		pnts=list((cordR2Rx+0.15):by1 (cordR2Rx+0.15):by2)
		dbSet(SHAPE pnts "points")) ;moves M2 connecting the M1 input of L.3 of C2 gate and M3 pin
		when((SHAPE~>layerName=="M2") &&((bx1==1.25)&&(by1==1.715))
		pnts=list((cordR2Rx+0.28):by1 (cordR2Rx+0.28):by2)
		dbSet(SHAPE pnts "points")) ;moves M2 connecting R.e between the C.2 gates in the upper half of the leaf cell
		when((SHAPE~>layerName=="M1") &&(((bx1==1.78)&&(by1==5.3))||((bx1==1.78)&&(by1==4.78))||((bx1==1.81)&&(by1==0.88))||((bx1==1.81)&&(by1==0.36)))
		bbox=list((ixy1-0.03):by1 (ixy1+0.19):by2)
		dbSet(SHAPE bbox "bBox"))
		when((SHAPE~>layerName=="M1")&&((bx1==1.78&&by1==5.785)||(bx1==1.78&&by1==1.365))
		when(cordRaRx>=(cordnrx2+0.03)
		pnts=list((cordRaRx+0.075):y1 ixy1:y2 ixy1:y3))
		when(cordRaRx<(cordnrx2+0.03)
		pnts=list((cordnrx2+0.1):y1 ixy1:y2 ixy1:y3))
		dbSet(SHAPE pnts "points"));moves M1 for R.3 and R.1 connecting to the centre of the inverter
		when((SHAPE~>layerName=="M1")&&(bx1==2.29&&by1==5.245)
		when(cordRaRx>=(cordnrx2+0.03)
		bbox=list((cordRaRx+0.035):by1 (cordRaRx+0.115):by2))
		when(cordRaRx<(cordnrx2+0.03)
		bbox=list((cordnrx2+0.06):by1 (cordRaRx+0.14):by2))
		dbSet(SHAPE bbox "bBox"))
		when((SHAPE~>layerName=="M1")&&(bx1==2.315&&by1==0.995)
		when(cordRaRx>=(cordnrx2+0.03)
		bbox=list((cordRaRx+0.055):by1 (cordRaRx+0.115):by2))
		when(cordRaRx<(cordnrx2+0.03)
		bbox=list((cordnrx2+0.07):by1 (cordnrx2+0.13):by2))
		dbSet(SHAPE bbox "bBox"))
		when((SHAPE~>layerName=="M1")&&((bx1==2.175&&by1==5.56)||(bx1==2.175&&by1==1.13))
		bbox=list((cordRaRx-0.115):by1 (cordRaRx-0.005):by2)
		dbSet(SHAPE bbox "bBox")) ; moves M1 shapes connecting poly inputs on the right side of gates R.3 and R.1with M2 of _r.3 and _r.1
		when((SHAPE~>layerName=="CO")&&(SHAPE~>net~>name=="_r.3")
		when(cordRaRx>=(cordnrx2+0.03)
		bbox=list((cordRaRx+0.055):by1 (cordRaRx+0.095):by2))
		when(cordRaRx<(cordnrx2+0.03)
		bbox=list((cordnrx2+0.08):by1 (cordnrx2+0.12):by2))
		dbSet(SHAPE bbox "bBox"))
		when((SHAPE~>layerName=="PO")&&(SHAPE~>net~>name=="_r.3")
		when(cordRaRx>=(cordnrx2+0.03)
		bbox=list((centreXY-0.18):by1 (cordRaRx+0.145):by2))
		when(cordRaRx<(cordnrx2+0.03)
		bbox=list((centreXY-0.18):by1 (cordnrx2+0.17):by2))
		dbSet(SHAPE bbox "bBox"))
		when((SHAPE~>layerName=="PO")&&(SHAPE~>net~>name=="_r.1")
		when(cordRaRx>=(cordnrx2+0.03)
		bbox=list((centreXY-0.18):by1 (cordRaRx+0.015):by2))
		when(cordRaRx<(cordnrx2+0.03)
		bbox=list((centreXY-0.18):by1 (cordnrx2+0.04):by2))
		dbSet(SHAPE bbox "bBox"))
		when((SHAPE~>layerName=="PO")&&(SHAPE~>net~>name=="_Reset")
		when(cordPCLx<=(ixy1-0.36)
		bbox=list((centreXY+0.18):by1 (cordPCLx-0.15):by2))
		when(cordPCLx>(ixy1-0.36)
		bbox=list((centreXY+0.18):by1 (ixy1-0.47):by2))
		dbSet(SHAPE bbox "bBox"))
		when((SHAPE~>layerName=="PO")&&(SHAPE~>net~>name=="_r.0")
		when(cordPCLx<=(ixy1-0.36)
		bbox=list((centreXY+0.18):by1 (cordPCLx-0.28):by2))
		when(cordPCLx>(ixy1-0.36)
		bbox=list((centreXY+0.18):by1 (ixy1-0.6):by2))
		dbSet(SHAPE bbox "bBox"))
		when((SHAPE~>layerName=="PO")&&(SHAPE~>net~>name=="_r.2")
		when(cordPCLx<=(ixy1-0.36)
		bbox=list((centreXY+0.18):by1 (cordPCLx-0.41):by2))
		when(cordPCLx>(ixy1-0.36)
		bbox=list((centreXY+0.18):by1 (ixy1-0.73):by2))
		dbSet(SHAPE bbox "bBox"))
		when((SHAPE~>layerName=="PO")&&(((bx1==1.145)&&(by1==0.57))||((bx1==1.145)&&(by1==0.31))||((bx1==1.17)&&(by1==4.99))||((bx1==1.17)&&(by1==4.73)))
		bbox=list((cordR2Rx+0.15):by1 (ixy1+0.1):by2)
		dbSet(SHAPE bbox "bBox")) ;moves poly connecting the L.3 inputs
		when((SHAPE~>layerName=="M1")&&(SHAPE~>net~>name=="_r.1")&&((by1==3.36)&&(by2==4.175))
		when(cordRaRx>=(cordnrx2+0.03)
		bbox=list((cordRaRx-0.085):by1 (cordRaRx-0.025):by2))
		when(cordRaRx<(cordnrx2+0.03)
		bbox=list((cordnrx2-0.06):by1 cordnrx2:by2))
		dbSet(SHAPE bbox "bBox")) ;moves M1 connecting poly inputs of NAND5 for _r.1
		when((SHAPE~>layerName=="CO")&&(SHAPE~>net~>name=="_r.1")
		when(cordRaRx>=(cordnrx2+0.03)
		bbox=list((cordRaRx-0.075):by1 (cordRaRx-0.035):by2))
		when(cordRaRx<(cordnrx2+0.03)
		bbox=list((cordnrx2-0.05):by1 (cordnrx2-0.01):by2))
		dbSet(SHAPE bbox "bBox"))
		when((SHAPE~>layerName=="CO")&&(SHAPE~>net~>name=="_Reset")
		when(cordPCLx<=(ixy1-0.36)
		bbox=list((cordPCLx-0.09):by1 (cordPCLx-0.05):by2))
		when(cordPCLx>(ixy1-0.36)
		bbox=list((ixy1-0.41):by1 (ixy1-0.37):by2))
		dbSet(SHAPE bbox "bBox"))
		when((SHAPE~>layerName=="CO")&&(SHAPE~>net~>name=="_r.0")
		when(cordPCLx<=(ixy1-0.36)
		bbox=list((cordPCLx-0.22):by1 (cordPCLx-0.18):by2))
		when(cordPCLx>(ixy1-0.36)
		bbox=list((ixy1-0.54):by1 (ixy1-0.5):by2))
		dbSet(SHAPE bbox "bBox"))
		when((SHAPE~>layerName=="CO")&&(SHAPE~>net~>name=="_r.2")
		when(cordPCLx<=(ixy1-0.36)
		bbox=list((cordPCLx-0.35):by1 (cordPCLx-0.31):by2))
		when(cordPCLx>(ixy1-0.36)
		bbox=list((ixy1-0.67):by1 (ixy1-0.63):by2))
		dbSet(SHAPE bbox "bBox"))
		when((SHAPE~>layerName=="M1")&&(SHAPE~>net~>name=="_r.1")&&((bx1==2.14)&&(by1==2.73))
		when(cordRaRx>=(cordnrx2+0.03)
		pnts=list((cordRaRx-0.025):y1 (cordRaRx-0.085):y2 (cordRaRx-0.085):y3 (cordRaRx-0.055):y4 (cordRaRx-0.055):y5 (cordRaRx-0.025):y6))
		when(cordRaRx<(cordnrx2+0.03)
		pnts=list(cordnrx2:y1 (cordnrx2-0.06):y2 (cordnrx2-0.06):y3 (cordRaRx-0.055):y4 (cordRaRx-0.055):y5 cordnrx2:y6))
		dbSet(SHAPE pnts "points")) ;moves M1 connecting M2 and M1 between poly inputs for _r.1
		when((SHAPE~>layerName=="M1")&&(bx1==1.315&&by1==3.155)
		when(cordPCLx<=(ixy1-0.36)
		bbox=list((cordPCLx-0.1):by1 (cordPCLx-0.04):by2))
		when(cordPCLx>(ixy1-0.36)
		bbox=list((ixy1-0.42):by1 (ixy1-0.36):by2))
		dbSet(SHAPE bbox "bBox")) ;moves M1 connecting the _Reset of NAND5 gate
		when((SHAPE~>layerName=="M1")&&(bx1==1.185&&by1==3.29)
		when(cordPCLx<=(ixy1-0.36)
		bbox=list((cordPCLx-0.23):by1 (cordPCLx-0.17):by2))
		when(cordPCLx>(ixy1-0.36)
		bbox=list((ixy1-0.55):by1 (ixy1-0.49):by2))
		dbSet(SHAPE bbox "bBox")) ;moves M1 connecting the _r.0 of NAND5 gate
		when((SHAPE~>layerName=="M1")&&(bx1==1.055&&by1==3.515)
		when(cordPCLx<=(ixy1-0.36)
		bbox=list((cordPCLx-0.36):by1 (cordPCLx-0.3):by2))
		when(cordPCLx>(ixy1-0.36)
		bbox=list((ixy1-0.68):by1 (ixy1-0.62):by2))
		dbSet(SHAPE bbox "bBox")) ;moves M1 connecting the _r.2 of NAND5 gate
		when((SHAPE~>layerName=="M1")&&(bx1==0.25&&by1==4.24)
		when((cordPCLx<=(ixy1-0.36))&&(cordR2Lx>=cordnx2)
		bbox=list((cordnx2+0.04):by1 (cordPCLx-0.3):by2))
		when((cordPCLx<=(ixy1-0.36))&&(cordR2Lx<cordnx2)
		bbox=list((cordR2Lx+0.08):by1 (cordPCLx-0.3):by2))
		when((cordPCLx>(ixy1-0.36))&&(cordR2Lx>=cordnx2)
		bbox=list((cordnx2+0.04):by1 (ixy1-0.62):by2))
		when((cordPCLx>(ixy1-0.36))&&(cordR2Lx<cordnx2)
		bbox=list((cordR2Lx+0.08):by1 (ixy1-0.62):by2))
		dbSet(SHAPE bbox "bBox")) ;moves M1 connecting the M2 with M1 of _r.2 of NAND5 gate
		when((SHAPE~>layerName=="M1")&&(bx1==0.25&&by1==3.29)
		when((cordPCLx<=(ixy1-0.36))&&(cordR2Lx>=cordnx2)
		bbox=list((cordnx2+0.04):by1 (cordPCLx-0.17):by2))
		when((cordPCLx<=(ixy1-0.36))&&(cordR2Lx<cordnx2)
		bbox=list((cordR2Lx+0.08):by1 (cordPCLx-0.17):by2))
		when((cordPCLx>(ixy1-0.36))&&(cordR2Lx>=cordnx2)
		bbox=list((cordnx2+0.04):by1 (ixy1-0.48):by2))
		when((cordPCLx>(ixy1-0.36))&&(cordR2Lx<cordnx2)
		bbox=list((cordR2Lx+0.08):by1 (ixy1-0.48):by2))
		dbSet(SHAPE bbox "bBox")) ;moves M1 connecting the M2 with M1 of _r.0 of NAND5 gate
		when((SHAPE~>layerName=="M1")&&(bx1==0.635&&by1==3.155)
		when(cordPCLx<=(ixy1-0.36)
		bbox=list(bx1:by1 (cordPCLx-0.04):by2))
		when(cordPCLx>(ixy1-0.36)
		bbox=list(bx1:by1 (ixy1-0.35):by2))
		dbSet(SHAPE bbox "bBox")) ;moves M1 connecting the M2 with M1 of _r.0 of NAND5 gate
		when((SHAPE~>layerName=="M1")&&((bx1==1.495&&by1==4.13)||(bx1==1.495&&by1==3.87)||(bx1==1.495&&by1==3.61)||(bx1==1.495&&by1==3.35))
		bbox=list((centreXY-0.18):by1 (ixy1-0.115):by2)
		dbSet(SHAPE bbox "bBox")) ;moves M1 connecting to the M2_M1 Vdd vias of NAND5 gate
		when((SHAPE~>layerName=="M1")&&(bx1==2.15&&by1==4.27)
		when(cordRaRx>=(cordnrx2+0.03)
		bbox=list((cordRaRx-0.055):by1 (cordRaRx+0.075):by2))
		when(cordRaRx<(cordnrx2+0.03)
		bbox=list((cordRaRx-0.055):by1 (cordnrx2+0.1):by2))
		dbSet(SHAPE bbox "bBox"))
		when((SHAPE~>layerName=="M1")&&((bx1==1.422&&by1==4.91&&by2==4.97&&bx2==2.225)||(bx1==1.415&&by1==0.49&&by2==0.55&&bx2==2.223))
		bbox=list((ixy1-0.2):by1 (cordRaRx-0.055):by2)
		dbSet(SHAPE bbox "bBox")) ;moves the _r.3 and _r.1 M1 wires connecting the output of C2 gate
		when((SHAPE~>layerName=="M1")&&((bx1==1.465&&by2==4.06)||(bx1==1.465&&by2==3.54)||(bx1==1.465&&by2==3.28))
		bbox=list((centreXY-0.25):by1 ixy1:by2)
		;pnts=list((ixy1+0.03):y1 (centreXY-0.18):y2 (centreXY-0.18):y3 (ixy1-0.03):y4 (ixy1-0.03):y5 (centreXY-0.18):y6 (centreXY-0.18):y7 (ixy1+0.03):y8)
		dbSet(SHAPE bbox "bBox")) ;moves M1 connecting rv of NAND5 gate in the centre
		when((SHAPE~>layerName=="M1")&&(bx1==1.345&&by2==4.32)
		bbox=list((centreXY-0.25):by1 ixy1:by2)
		when(cordPCLx<=(ixy1-0.36)
		pnts=list((centreXY-0.15):y1 (cordPCLx-0.04):y2 (cordPCLx-0.04):y3 (centreXY-0.15):y4 (centreXY-0.15):y5 (cordPCLx+0.02):y6 (cordPCLx+0.02):y7 (centreXY-0.15):y8))
		when(cordPCLx>(ixy1-0.36)
		pnts=list((centreXY-0.15):y1 (ixy1-0.42):y2 (ixy1-0.42):y3 (centreXY-0.15):y4 (centreXY-0.15):y5 (ixy1-0.36):y6 (ixy1-0.36):y7 (centreXY-0.15):y8))
		dbSet(SHAPE pnts "points")) ;moves M1 connecting rv of NAND5 gate on the left side
		when((SHAPE~>layerName=="M1")&&(bx1==1.465&&by2==3.8)
		bbox=list((centreXY-0.25):by1 (centreXY+0.25):by2)
		dbSet(SHAPE bbox "bBox")) ;moves M1 connecting rv of the output of the NAND5 gate
		when((SHAPE~>layerName=="PP")&&(bx1==2.545&&by1==2.335&&bx2==2.6&&by2==2.86)
		when(cordRaRx>=(cordnrx2+0.03)
		bbox=list((cordRaRx+0.13):by1 (cordRaRx+0.185):by2))
		when(cordRaRx<(cordnrx2+0.03)
		bbox=list((cordnrx2+0.155):by1 (cordnrx2+0.21):by2))
		dbSet(SHAPE bbox "bBox")) ;moves PP on the right side of NPLUG
		when((SHAPE~>layerName=="PP")&&(bx1==0&&by1==3.38&&bx2==0.08&&by2==3.905)
		when(cordR2Lx>=cordnx2
		bbox=list((cordnx2-0.21):by1 (cordnx2-0.13):by2))
		when(cordR2Lx<cordnx2
		bbox=list((cordR2Lx-0.16):by1 (cordR2Lx-0.08):by2))
		dbSet(SHAPE bbox "bBox")) ;moves PP on the leftt side of NPLUG
		when((SHAPE~>layerName=="M1")&&(bx1==1.28&&by2==4.885)
		when(cordRaRx>=(cordnrx2+0.03)
		pnts=list((ixy1-0.515):y1 (cordRaRx+0.075):y2 (cordRaRx+0.075):y3))
		when(cordRaRx<(cordnrx2+0.03)
		pnts=list((ixy1-0.515):y1 (cordnrx2+0.1):y2 (cordnrx2+0.1):y3))
		dbSet(SHAPE pnts "points")) ;moves M1 connecting R.e on M2 and M1 on the poly inputs of C.2 gate in R.3 region
		when((SHAPE~>layerName=="M1")&&(bx1==0.785&&by2==4.45)
		bbox=list(bx1:by1 (centreXY-0.15):by2)
		dbSet(SHAPE bbox "bBox")) ;moves M1 connecting Vdd and with the PMOS rv.P10
		when((SHAPE~>layerName=="M1")&&((bx1==1.265&&by2==1.725)||(bx1==1.27&&by2==6.13))
		bbox=list((cordpx2+0.07):by1 (cordpx2+0.13):by2)
		dbSet(SHAPE bbox "bBox")) ;moves M1 connecting the M2_M1 vias and the R.e inputs of C.2 gates
		when((SHAPE~>layerName=="M1")&&(bx1==2.3&&by1==0.995)
		pnts=list((cordRaRx+0.075):by1 (cordRaRx+0.075):by2)
		dbSet(SHAPE pnts "points"))
		when((SHAPE~>layerName=="M2")&&(bx1==1.25&&by1==0.085)&&(SHAPE~>net~>name=="R.e")
		pnts=list((ixy1-0.515):by1 (ixy1-0.515):by2)
		dbSet(SHAPE pnts "points"));moves M2 R.e connecting all the C2 gates
		when((SHAPE~>layerName=="M1")&&((bx1==1.225&&by2==1.725)||(bx1==1.275&&by2==6.13))
		bbox=list((cordpx2+0.1):by1 (ixy1-0.515):by2)
		dbSet(SHAPE bbox "bBox")) ;moves M1 connecting R.e on M2 with R.e on the inputs of C2 gates
		when((SHAPE~>layerName=="M1")&&(bx1==1.13&&by2==0.17)
		bbox=list((cordR2Rx+0.15):by1 (ixy1-0.515):by2)
		dbSet(SHAPE bbox "bBox")) ;moves M1 connecting the R.e on M2 in the bottom portion
		when((SHAPE~>layerName=="M2")&&(SHAPE~>net~>name=="_RESET")
		when(cordR2Lx>=cordnx2
		pnts=list((cordnx2-0.1):by1 (cordnx2-0.1):by2))
		when(cordR2Lx<cordnx2
		pnts=list((cordR2Lx-0.05):by1 (cordR2Lx-0.05):by2))
		dbSet(SHAPE pnts "points")) ;moves M2 connecting _RESET
		when((SHAPE~>layerName=="M1")&&(SHAPE~>net~>name=="_RESET")
		when(cordR2Lx>=cordnx2
		bbox=list((cordnx2-0.1):by1 (cordResRx+0.08):by2))
		when(cordR2Lx<cordnx2
		bbox=list((cordR2Lx-0.05):by1 (cordResRx+0.08):by2))
		dbSet(SHAPE bbox "bBox")) ;moves M1 connecting M2 _RESET with the poly input of the gate
		when((SHAPE~>layerName=="M1")&&(SHAPE~>net~>name=="Reset")
		pnts=list(x1:y1 (cordUResRx-0.08):y2 (cordUResRx-0.08):y3)
		dbSet(SHAPE pnts "points")) ;moves M1 connecting the Reset input of _Reset gate
		when((SHAPE~>layerName=="M2")&&((bx1==1.395&&by2==5.355)||(bx1==1.395&&by2==0.935))
		bbox=list((ixy1-0.415):by1 (ixy1-0.355):by2)
		dbSet(SHAPE bbox "bBox")) ;moves the M2 internal nets connecting C2 gates of 2nd coloumn on the left side
		when((SHAPE~>layerName=="PO")&&(bx1==0.99&&bx2==1.07)
		bbox=list(cordR2Rx:by1 (cordR2Rx+0.08):by2)
		dbSet(SHAPE bbox "bBox")) ;moves cut_poly associated with the R.0 and R.2 gates
		when((SHAPE~>layerName=="PO")&&(bx1==1.37&&bx2==1.45)
		bbox=list((cordpx2+0.17):by1 (cordpx2+0.25):by2)
		dbSet(SHAPE bbox "bBox")) ;moves cut_poly associated with the R.1 and R.3 gates
		when((SHAPE~>layerName=="M1")&&((bx1==1.4&&by1==5.3)||(bx1==1.37&&by1==4.78)||(bx1==1.4&&by1==0.88)||(bx1==1.37&&by1==0.36))
		bbox=list((ixy1-0.385):by1 (ixy1-0.09):by2)
		dbSet(SHAPE bbox "bBox")) ;moves M1 connecting the M2 which is connecting the internal nets on the PMOS side of the C2 gate in 2nd coloumn
		when((SHAPE~>layerName=="OD")&&((bx1==1.52&&by1==5.045)||(bx1==1.52&&by1==4.785)||(bx1==1.52&&by1==0.625)||(bx1==1.52&&by1==0.365))
		bbox=list((ixy1-0.29):by1 (ixy1-0.11):by2)
		dbSet(SHAPE bbox "bBox")) ;moves the OD in the C2 gates of 2nd coloumn i.e in case of internal nets
		when((SHAPE~>layerName=="CO")&&((bx1==1.54&&by1==5.05)||(bx1==1.54&&by1==4.79)||(bx1==1.54&&by1==0.63)||(bx1==1.54&&by1==0.37))
		bbox=list((ixy1-0.27):by1 (ixy1-0.23):by2)
		dbSet(SHAPE bbox "bBox")) ;moves CO used for inernal nets in the C2 gates of 2nd colomn
		when((SHAPE~>layerName=="CO")&&((bx1==1.65&&by1==5.05)||(bx1==1.65&&by1==4.79)||(bx1==1.65&&by1==0.63)||(bx1==1.65&&by1==0.37))
		bbox=list((ixy1-0.16):by1 (ixy1-0.12):by2)
		dbSet(SHAPE bbox "bBox")) ;moves CO used for inernal nets in the C2 gates of 2nd colomn
		when((SHAPE~>layerName=="M1")&&((bx1==1.25&&by1==5.04)||(bx1==1.25&&by1==0.62))
		pnts=list((ixy1-0.09):y1 cordPLx1:y2 cordPLx1:y3 (ixy1-0.09):y4 (ixy1-0.09):y5 cordPLx2:y6 cordPLx2:y7 (ixy1-0.09):y8)
		dbSet(SHAPE pnts "points")) ;moves M1 connecting internal nets n left side of C2 gate in 2nd coloumn
		when((SHAPE~>layerName=="M1")&&(bx1==2.08&&by1==2.305)
		when(cordRaRx>=(cordnrx2+0.03)
		pnts=list((cordRaRx+0.055):y1 (cordRaRx-0.005):y2 (cordRaRx-0.005):y3 (ixy1+0.195):y4 (ixy1+0.195):y5 (cordRaRx+0.055):y6))
		when(cordRaRx<(cordnrx2+0.03)
		pnts=list((cordnrx2+0.08):y1 (cordnrx2+0.02):y2 (cordnrx2+0.02):y3 (ixy1+0.195):y4 (ixy1+0.195):y5 (cordnrx2+0.08):y6))
		dbSet(SHAPE pnts "points"))
		when((SHAPE~>layerName=="M3")&&((SHAPE~>net~>name=="R.2")||(SHAPE~>net~>name=="R.0"))
		when(cordRaRx>=(cordnrx2+0.03)
		bbox=list(bx1:by1 (cordRaRx+0.145):by2))
		when(cordRaRx<(cordnrx2+0.03)
		bbox=list(bx1:by1 (cordnrx2+0.17):by2))
		dbSet(SHAPE bbox "bBox")) ;moves M3 pins R.2 and R.0
		when((SHAPE~>layerName=="M3")&&(SHAPE~>net~>name=="R.1")
		when(cordRaRx>=(cordnrx2+0.03)
		bbox=list(ixy1:by1 (cordRaRx+0.145):by2))
		when(cordRaRx<(cordnrx2+0.03)
		bbox=list(ixy1:by1 (cordnrx2+0.17):by2))
		dbSet(SHAPE bbox "bBox")) ;moves M3 pins R.1
		when((SHAPE~>layerName=="M3")&&(SHAPE~>net~>name=="R.e")
		when(cordRaRx>=(cordnrx2+0.03)
		bbox=list((ixy1-0.515):by1 (cordRaRx+0.145):by2))
		when(cordRaRx<(cordnrx2+0.03)
		bbox=list((ixy1-0.515):by1 (cordnrx2+0.17):by2))
		dbSet(SHAPE bbox "bBox")) ;moves M3 pins R.e
		when((SHAPE~>layerName=="M3")&&(SHAPE~>net~>name=="R.3")
		when(cordRaRx>=(cordnrx2+0.03)
		bbox=list(ixy1:by1 (cordRaRx+0.145):by2))
		when(cordRaRx<(cordnrx2+0.03)
		bbox=list(ixy1:by1 (cordnrx2+0.17):by2))
		dbSet(SHAPE bbox "bBox")) ;moves M3 pins R.3
		when((SHAPE~>layerName=="M3")&&(SHAPE~>net~>name=="L.0")
		when(cordR2Lx>=cordnx2
		bbox=list((cordnx2-0.17):by1 Lpinx:by2))
		when(cordR2Lx<cordnx2
		bbox=list((cordR2Lx-0.12):by1 Lpinx:by2))
		dbSet(SHAPE bbox "bBox")) ;moves M3 pins L.0
		when((SHAPE~>layerName=="M3")&&(SHAPE~>net~>name=="L.1")
		when(cordR2Lx>=cordnx2
		bbox=list((cordnx2-0.17):by1 (ixy1-0.385):by2))
		when(cordR2Lx<cordnx2
		bbox=list((cordR2Lx-0.12):by1 (ixy1-0.385):by2))
		dbSet(SHAPE bbox "bBox")) ;moves M3 pins L.1
		when((SHAPE~>layerName=="M3")&&(SHAPE~>net~>name=="L.e")
		when(cordR2Lx>=cordnx2
		bbox=list((cordnx2-0.17):by1 bx2:by2))
		when(cordR2Lx<cordnx2
		bbox=list((cordR2Lx-0.12):by1 bx2:by2))
		dbSet(SHAPE bbox "bBox")) ;moves M3 pins L.e
		when((SHAPE~>layerName=="M3")&&(SHAPE~>net~>name=="L.2")
		when(cordR2Lx>=cordnx2
		bbox=list((cordnx2-0.17):by1 Lpinx:by2))
		when(cordR2Lx<cordnx2
		bbox=list((cordR2Lx-0.12):by1 Lpinx:by2))
		dbSet(SHAPE bbox "bBox")) ;moves M3 pins L.2
		when((SHAPE~>layerName=="M3")&&(SHAPE~>net~>name=="L.3")
		when(cordR2Lx>=cordnx2
		bbox=list((cordnx2-0.17):by1 (cordR2Rx+0.15):by2))
		when(cordR2Lx<cordnx2
		bbox=list((cordR2Lx-0.12):by1 (cordR2Rx+0.15):by2))
		dbSet(SHAPE bbox "bBox")) ;moves M3 pins L.3
		when((SHAPE~>layerName=="M3")&&(SHAPE~>net~>name=="_RESET")
		when((cordRaRx>=(cordnrx2+0.03))&&(cordR2Lx>=cordnx2)
		bbox=list((cordnx2-0.17):by1 (cordRaRx+0.145):by2))
		when((cordRaRx>=(cordnrx2+0.03))&&(cordR2Lx<cordnx2)
		bbox=list((cordR2Lx-0.12):by1 (cordRaRx+0.145):by2))
		when((cordRaRx<(cordnrx2+0.03))&&(cordR2Lx>=cordnx2)
		bbox=list((cordnx2-0.17):by1 (cordnrx2+0.17):by2))
		when((cordRaRx<(cordnrx2+0.03))&&(cordR2Lx<cordnx2)
		bbox=list((cordR2Lx-0.12):by1 (cordnrx2+0.17):by2))
		dbSet(SHAPE bbox "bBox")) ;moves M3 pins _RESET
		when((SHAPE~>layerName=="NP")&&(bx1==1.64&&by1==1.785)
		bbox=list((ixy1-0.17):by1 ixy1:by2)
		dbSet(SHAPE bbox "bBox")); moves NP associated with the PPLUG
		when((SHAPE~>layerName=="PO")&&(bx1==2.56&&bx2==2.6)
		when(cordRaRx>=(cordnrx2+0.03)
		bbox=list((cordRaRx+0.145):by1 (cordRaRx+0.185):by2))
		when(cordRaRx<(cordnrx2+0.03)
		bbox=list((cordnrx2+0.17):by1 (cordnrx2+0.21):by2))
		dbSet(SHAPE bbox "bBox")) ; moves CUT_POLY on the right of the leaf cell
		when((SHAPE~>layerName=="PO")&&(by2==6.24&&bx2==0.04)
		when(cordR2Lx>=cordnx2
		bbox=list((cordnx2-0.21):by1 (cordnx2-0.17):by2))
		when(cordR2Lx<cordnx2
		bbox=list((cordR2Lx-0.12):by1 (cordR2Lx-0.16):by2))
		DIFF=0-cordnx2
		dbSet(SHAPE bbox "bBox")) ; moves CUT_POLY on the left of the leaf cell
		when((SHAPE~>layerName=="PO")&&((bx2==2.6&&by2==0.08&&bx1==0)||(bx2==2.6&&by2==0.21&&bx1==0)||(bx2==2.6&&by2==0.34&&bx1==0)||(bx2==2.6&&by2==0.47&&bx1==0)||(bx2==2.6&&by2==0.6&&bx1==0)||(bx2==2.6&&by2==0.73&&bx1==0)||(bx2==2.6&&by2==0.86&&bx1==0)||(bx2==2.6&&by2==0.99&&bx1==0)||(bx2==2.6&&by2==1.12&&bx1==0)||(bx2==2.6&&by2==1.25&&bx1==0)||(bx2==2.6&&by2==1.38&&bx1==0)||(bx2==2.6&&by2==1.51&&bx1==0)||(bx2==2.6&&by2==1.64&&bx1==0)||(bx2==2.6&&by2==1.77&&bx1==0)||(bx2==2.6&&by2==2.16&&bx1==0)||(bx2==2.6&&by2==2.29&&bx1==0)||(bx2==2.6&&by2==2.68&&bx1==0)||(bx2==2.6&&by2==2.81&&bx1==0)||(bx2==2.6&&by2==2.94&&bx1==0)||(bx2==2.6&&by2==3.07&&bx1==0)||(bx2==2.6&&by2==3.2&&bx1==0)||(bx2==2.6&&by2==3.33&&bx1==0)||(bx2==2.6&&by2==3.72&&bx1==0)||(bx2==2.6&&by2==3.85&&bx1==0)||(bx2==2.6&&by2==3.98&&bx1==0)||(bx2==2.6&&by2==4.11&&bx1==0)||(bx2==2.6&&by2==4.24&&bx1==0)||(bx2==2.6&&by2==4.37&&bx1==0)||(bx2==2.6&&by2==4.5&&bx1==0)||(bx2==2.6&&by2==4.63&&bx1==0)||(bx2==2.6&&by2==4.76&&bx1==0)||(bx2==2.6&&by2==4.89&&bx1==0)||(bx2==2.6&&by2==5.02&&bx1==0)||(bx2==2.6&&by2==5.15&&bx1==0)||(bx2==2.6&&by2==5.28&&bx1==0)||(bx2==2.6&&by2==5.41&&bx1==0)||(bx2==2.6&&by2==5.54&&bx1==0)||(bx2==2.6&&by2==5.67&&bx1==0)||(bx2==2.6&&by2==5.8&&bx1==0)||(bx2==2.6&&by2==5.93&&bx1==0)||(bx2==2.6&&by2==6.06&&bx1==0)||(bx2==2.6&&by2==6.19&&bx1==0))
		when((cordRaRx>=(cordnrx2+0.03))&&(cordR2Lx>=cordnx2)
		bbox=list((cordnx2-0.21):by1 (cordRaRx+0.185):by2))
		when((cordRaRx>=(cordnrx2+0.03))&&(cordR2Lx<cordnx2)
		bbox=list((cordR2Lx-0.16):by1 (cordRaRx+0.185):by2))
		when((cordRaRx<(cordnrx2+0.03))&&(cordR2Lx>=cordnx2)
		bbox=list((cordnx2-0.21):by1 (cordnrx2+0.21):by2))
		when((cordRaRx<(cordnrx2+0.03))&&(cordR2Lx<cordnx2)
		bbox=list((cordR2Lx-0.16):by1 (cordnrx2+0.21):by2))
		dbSet(SHAPE bbox "bBox")) ;moves dummy poly grid layers
		when((SHAPE~>layerName=="M3")&&((bx1==0&&by2==0.095&&bx2==2.6)||(bx1==0&&by2==1.535&&bx2==2.6)||(bx1==0&&by2==1.655&&bx2==2.6)||(bx1==0&&by2==3.095&&bx2==2.6)||(bx1==0&&by2==3.215&&bx2==2.6)||(bx1==0&&by2==4.655&&bx2==2.6)||(bx1==0&&by2==4.775&&bx2==2.6)||(bx1==0&&by2==6.215&&bx2==2.6))
		when((cordRaRx>=(cordnrx2+0.03))&&(cordR2Lx>=cordnx2)
		bbox=list((cordnx2-0.21):by1 (cordRaRx+0.185):by2))
		when((cordRaRx>=(cordnrx2+0.03))&&(cordR2Lx<cordnx2)
		bbox=list((cordR2Lx-0.16):by1 (cordRaRx+0.185):by2))
		when((cordRaRx<(cordnrx2+0.03))&&(cordR2Lx>=cordnx2)
		bbox=list((cordnx2-0.21):by1 (cordnrx2+0.21):by2))
		when((cordRaRx<(cordnrx2+0.03))&&(cordR2Lx<cordnx2)
		bbox=list((cordR2Lx-0.16):by1 (cordnrx2+0.21):by2))
		LeftLeaf=caar(bbox)
		RightLeaf=caadr(bbox)-LeftLeaf
		dbSet(SHAPE bbox "bBox")) ;moves M3 power grids
		when((SHAPE~>layerName=="prBoundary")
		dbDeleteObject(SHAPE)
		when((cordRaRx>=(cordnrx2+0.03))&&(cordR2Lx>=cordnx2)
		pnts=list((cordnx2-0.21):by1 (cordnx2-0.21):by2 (cordRaRx+0.185):by2 (cordRaRx+0.185):by1))
		when((cordRaRx>=(cordnrx2+0.03))&&(cordR2Lx<cordnx2)
		pnts=list((cordR2Lx-0.16):by1 (cordR2Lx-0.16):by2 (cordRaRx+0.185):by2 (cordRaRx+0.185):by1))
		when((cordRaRx<(cordnrx2+0.03))&&(cordR2Lx>=cordnx2)
		pnts=list((cordnx2-0.21):by1 (cordnx2-0.21):by2 (cordnrx2+0.21):by2 (cordnrx2+0.21):by1))
		when((cordRaRx<(cordnrx2+0.03))&&(cordR2Lx<cordnx2)
		pnts=list((cordR2Lx-0.16):by1 (cordR2Lx-0.16):by2 (cordnrx2+0.21):by2 (cordnrx2+0.21):by1))
		dbCreatePRBoundary(CellView pnts)) ;moves PrBoundary
		when((SHAPE~>layerName=="PO")&&((by2==3.59&&bx2==2.6&&bx1==0.295)||(by2==3.46&&bx2==2.6&&bx1==0.295))
		when(cordRaRx>=(cordnrx2+0.03)
		bbox=list((cordnx2+0.06):by1 (cordRaRx+0.185):by2))
		when(cordRaRx<(cordnrx2+0.03)
		bbox=list((cordnx2+0.06):by1 (cordnrx2+0.21):by2))
		dbSet(SHAPE bbox "bBox")) ;moves poly grids w.r.t 1st NPLUG on left side
		when((SHAPE~>layerName=="PO")&&((by2==2.55&&bx2==2.095&&bx1==0)||(by2==2.42&&bx1==0&&bx2==2.095))
		when(cordR2Lx>=cordnx2
		bbox=list((cordnx2-0.21):by1 (cordRaRx-0.115):by2))
		when(cordR2Lx<cordnx2
		bbox=list((cordR2Lx-0.16):by1 (cordRaRx-0.115):by2))
		dbSet(SHAPE bbox "bBox")) ;moves poly grids w.r.t 2nd NPLUG on right side
		when((SHAPE~>layerName=="PO")&&((by2==2.03&&bx1==0&&bx2==1.535)||(by2==1.9&&bx1==0&&bx2==1.535))
		when(cordR2Lx>=cordnx2
		bbox=list((cordnx2-0.21):by1 (ixy1-0.31):by2))
		when(cordR2Lx<cordnx2
		bbox=list((cordR2Lx-0.16):by1 (ixy1-0.31):by2))
		dbSet(SHAPE bbox "bBox"))  ;moves poly grids w.r.t 2nd PPLUG on left side
		when((SHAPE~>layerName=="PO")&&((by2==1.9&&bx1==1.89&&bx2==2.6)||(by2==2.03&&bx1==1.89&&bx2==2.6))
		when(cordRaRx>=(cordnrx2+0.03)
		bbox=list((ixy1+0.08):by1 (cordRaRx+0.185):by2))
		when(cordRaRx<(cordnrx2+0.03)
		bbox=list((ixy1+0.08):by1 (cordnrx2+0.21):by2))
		dbSet(SHAPE bbox "bBox"))  ;moves poly grids w.r.t 2nd PPLUG on right side
		when((SHAPE~>layerName=="M1")&&(by2==3.56&&bx2==0.365&&bx1==0.115)
		when(cordR2Lx>=cordnx2
		bbox=list((cordnx2-0.08):by1 bx2:by2))
		when(cordR2Lx<cordnx2
		bbox=list((cordR2Lx-0.05):by1 bx2:by2))
		dbSet(SHAPE bbox "bBox"))
		when((SHAPE~>layerName=="M1")&&(bx1==1.425&&bx2==2.385)
		when(cordRaRx>=(cordnrx2+0.03)
		pnts=list((ixy1-0.385):y1 (cordRaRx+0.075):y2))
		when(cordRaRx<(cordnrx2+0.03)
		pnts=list((ixy1-0.385):y1 (cordnrx2+0.1):y2))
		dbSet(SHAPE pnts "points")) ;moves M1 connecting the L.1 M3 pin
		when((SHAPE~>layerName=="M2")&&(SHAPE~>net~>name=="L.3")
		pnts=list((cordR2Rx+0.15):by1 (cordR2Rx+0.15):by2)
		dbSet(SHAPE pnts "points")) ;moves M2 connecting the L.3 pin with the input of the C.2 gate
		when((SHAPE~>layerName=="NP")&&(bx1==0&&by2==6.24&&bx2==0.635)
		when(cordR2Lx>=cordnx2
		pnts=list(x1:y1 (cordnx2-0.21):y2 (cordnx2-0.21):y3 (cordnx2+0.025):y4 (cordnx2+0.025):y5 (cordnx2-0.21):y6 (cordnx2-0.21):y7 x8:y8))
		when(cordR2Lx<cordnx2
		pnts=list(x1:y1 (cordR2Lx-0.16):y2 (cordR2Lx-0.16):y3 (cordR2Lx+0.075):y4 (cordR2Lx+0.075):y5 (cordR2Lx-0.16):y6 (cordR2Lx-0.16):y7 x8:y8))
		dbSet(SHAPE pnts "points")) ; moves NP on the left side of the gates in 1st coloumn
		when((SHAPE~>layerName=="PP")&&(bx1==0.635&&by2==2.99&&bx2==1.81)
		pnts=list(ixy1:y1 (ixy1-0.275):y2 (ixy1-0.275):y3 ixy1:y4 ixy1:y5 x6:y6 x7:y7 ixy1:y8)
		dbSet(SHAPE pnts "points")) ;moves PP in the lower portion
		when((SHAPE~>layerName=="NW")&&(bx1==0.635&&by2==2.99&&bx2==1.81)
		bbox=list(bx1:by1 ixy1:by2)
		dbSet(SHAPE bbox "bBox")) ;moves NW in the lower portion
		when((SHAPE~>layerName=="PM")&&(bx1==0.635&&by2==2.99&&bx2==1.81)
		bbox=list(bx1:by1 ixy1:by2)
		dbSet(SHAPE bbox "bBox")) ;moves PM in the lower portion
		when((SHAPE~>layerName=="PP")&&(bx1==0.635&&by2==6.07&&bx2==1.81)
		bbox=list(bx1:by1 ixy1:by2)
		dbSet(SHAPE bbox "bBox")) ;moves PP in the Upper portion
		when((SHAPE~>layerName=="NW")&&(bx1==0.635&&by2==6.11&&bx2==1.81)
		bbox=list(bx1:by1 ixy1:by2)
		dbSet(SHAPE bbox "bBox")) ;moves NW in the Upper portion
		when((SHAPE~>layerName=="PM")&&(bx1==0.635&&by2==6.11&&bx2==1.81)
		bbox=list(bx1:by1 ixy1:by2)
		dbSet(SHAPE bbox "bBox")) ;moves PM in the Upper portion
		when(((SHAPE~>layerName=="PP")||(SHAPE~>layerName=="PM")||(SHAPE~>layerName=="NW"))&&(bx1==0.635&&by2==4.55&&bx2==1.655)
		bbox=list(bx1:by1 (centreXY+0.01):by2)
		dbSet(SHAPE bbox "bBox")) ;moves PP/NW/PM in the middle portion
		when((SHAPE~>layerName=="NP")&&(bx1==1.81&&by2==2.99&&bx2==2.6)
		when(cordRaRx>=(cordnrx2+0.03)
		pnts=list((cordRaRx+0.185):y1 (cordRaRx-0.08):y2 (cordRaRx-0.08):y3 (cordRaRx+0.185):y4 (cordRaRx+0.185):y5 ixy1:y6 ixy1:y7 (cordRaRx+0.185):y8))
		when(cordRaRx<(cordnrx2+0.03)
		pnts=list((cordnrx2+0.21):y1 (cordnrx2-0.055):y2 (cordnrx2-0.055):y3 (cordnrx2+0.21):y4 (cordnrx2+0.21):y5 ixy1:y6 ixy1:y7 (cordnrx2+0.21):y8))
		dbSet(SHAPE pnts "points")) ;moves NP on the right side in the lower portion
		when((SHAPE~>layerName=="NP")&&(bx1==1.655&&by2==6.24&&bx2==2.6)
		when(cordRaRx>=(cordnrx2+0.03)
		pnts=list((cordRaRx+0.185):y1 ixy1:y2 ixy1:y3 (centreXY+0.01):y4 (centreXY+0.01):y5 (cordRaRx+0.185):y6))
		when(cordRaRx<(cordnrx2+0.03)
		pnts=list((cordnrx2+0.21):y1 ixy1:y2 ixy1:y3 (centreXY+0.01):y4 (centreXY+0.01):y5 (cordnrx2+0.21):y6))
		dbSet(SHAPE pnts "points")) ;moves NP on the right side in the Upper portion
		when((SHAPE~>layerName=="NP")&&((bx1==0.635&&by2==0.17&&bx2==1.81)||(bx1==0.635&&by2==6.24&&bx2==1.81))
		bbox=list(bx1:by1 ixy1:by2)
		dbSet(SHAPE bbox "bBox")); moves NP in the lower and upper portions of NW
		when((SHAPE~>layerName=="M3")&&((xy1==2.165&&xy2==1.885)||(xy1==2.24&&xy2==5.005)||(xy1==1.8&&xy2==4.485)||(xy1==2.045&&xy2==2.925)||(xy1==1.84&&xy2==0.325))
		orgn=(ixy1+0.1:xy2)
		dbSet(SHAPE orgn "xy")) ;moves labels of R pins on M3

	))

	foreach(VIA CellView->vias
		(let (vx1 vy1 bx1 by1 bx2 by2 vx1 vy1 orgn)
		bx1=caar(VIA~>bBox)
		by1=cadar(VIA~>bBox)
		bx2=caadr(VIA~>bBox)
		by2=cadadr(VIA~>bBox)
		vx1=car(VIA~>origin)
		vy1=cadr(VIA~>origin)
		when(((VIA~>viaHeader~>viaDefName=="M2_M1")|| (VIA~>viaHeader~>viaDefName=="M3_M2"))&& ((VIA~>net~>name=="L.2")||(VIA~>net~>name=="L.0"))
		when(cordR2Lx>=cordnx2
		orgn=(cordnx2-0.1:vy1))
		when(cordR2Lx<cordnx2
		orgn=(cordR2Lx-0.05:vy1))
		dbSet(VIA orgn "origin"))
		when(((VIA~>viaHeader~>viaDefName=="M2_M1")|| (VIA~>viaHeader~>viaDefName=="M3_M2"))&& (VIA~>net~>name=="R.3")
		when(cordRaRx>=(cordnrx2+0.03)
		orgn=(cordRaRx+0.075:vy1))
		when(cordRaRx<(cordnrx2+0.03)
		orgn=(cordnrx2+0.1:vy1))
		dbSet(VIA orgn "origin"))
		when(((VIA~>viaHeader~>viaDefName=="M2_M1")|| (VIA~>viaHeader~>viaDefName=="M3_M2"))&&(VIA~>net~>name=="L.1")&&(vx1==2.325)
		when(cordRaRx>=(cordnrx2+0.03)
		orgn=(cordRaRx+0.075:vy1))
		when(cordRaRx<(cordnrx2+0.03)
		orgn=(cordnrx2+0.1:vy1))
		dbSet(VIA orgn "origin"))
		when(((VIA~>viaHeader~>viaDefName=="M2_M1")|| (VIA~>viaHeader~>viaDefName=="M3_M2"))&& (VIA~>net~>name=="R.1")
		orgn=(ixy1:vy1)
		dbSet(VIA orgn "origin"))
		when((VIA~>viaHeader~>viaDefName=="M2_M1")&& ((VIA~>net~>name=="_r.2")||(VIA~>net~>name=="_r.0"))
		when(cordR2Lx>=cordnx2
		orgn=(cordnx2+0.04:vy1))
		when(cordR2Lx<cordnx2
		orgn=(cordR2Lx+0.08:vy1))
		dbSet(VIA orgn "origin"))
		when((VIA~>viaHeader~>viaDefName=="M2_M1")&& ((bx1==1.78)&&(bx2==1.84))
		orgn=(ixy1:vy1)
		dbSet(VIA orgn "origin"))
		when(((VIA~>viaHeader~>viaDefName=="M2_M1")||(VIA~>viaHeader~>viaDefName=="M3_M2"))&& (vx1==1.155)&&(VIA~>net~>name=="L.3")
		orgn=((cordR2Rx+0.15):vy1)
		dbSet(VIA orgn "origin"))
		when(((VIA~>viaHeader~>viaDefName=="M2_M1")||(VIA~>viaHeader~>viaDefName=="M3_M2"))&&(VIA~>net~>name=="_RESET")
		when(cordR2Lx>=cordnx2
		orgn=((cordnx2-0.1):vy1))
		when(cordR2Lx<cordnx2
		orgn=((cordR2Lx-0.05):vy1))
		dbSet(VIA orgn "origin"))
		when(((VIA~>viaHeader~>viaDefName=="M2_M1")||(VIA~>viaHeader~>viaDefName=="M3_M2"))&&(vx1==1.425)
		orgn=((ixy1-0.385):vy1)
		dbSet(VIA orgn "origin"))
		when(((VIA~>viaHeader~>viaDefName=="M2_M1")||(VIA~>viaHeader~>viaDefName=="M3_M2"))&& (vx1==1.28)&&(VIA~>net~>name=="R.e")
		orgn=((ixy1-0.515):vy1)
		dbSet(VIA orgn "origin"))
		when((VIA~>viaHeader~>viaDefName=="M2_M1")&& ((VIA~>net~>name=="_r.3")||(VIA~>net~>name=="_r.1"))
		orgn=(cordRaRx-0.06:vy1)
		dbSet(VIA orgn "origin"))
		when((VIA~>viaHeader~>viaDefName=="M2_M1")&& (VIA~>net~>name=="rv")
		orgn=(ixy1:vy1)
		dbSet(VIA orgn "origin"))
		when((VIA~>viaHeader~>viaDefName=="M3_M2_R_H")&& (vx1==2.005)
		orgn=(ixy1+0.195:vy1)
		dbSet(VIA orgn "origin"))
		when((VIA~>viaHeader~>viaDefName=="M3_M2_R_H")&& (vx1==1.615)
		orgn=(ixy1-0.195:vy1)
		dbSet(VIA orgn "origin"))
	))

))

(defun MakeBuffer1 (CellView ViewName)
	(let (text parameter1 parameter2 parameter3 parameter4 cordM2_M1 INST SHAPE VIA cordnx1 cordnx2 cordpx1 cordpx2 Lpinx cordR0y1 cordR0y2 cordR2y2 NWidth PWidth LePWidth ResPWidth rvNWidth rvPWidth n_contt p_contt cordR1y2 cordrvx1 cordrvx2 cordrvx3 cordrvx4 cordrvy2 cordResx2 cordresx1 cordLex1 cordLex2 cordLex3 cordLex4 cordLey2 cordR1x3 cordR2x2 cordR2x1 cordR1x2 cordR1x1 ActualLeftPoly)
	fl = infile("Parameter.txt")
	while( gets(k fl) != nil
  	text = parseString( k " \n")
	parameter1 = nth(0 text)
	parameter2 = nth(1 text)
	parameter3 = nth(2 text)
	parameter4 = nth(3 text)
 ;setting instance parameters as per the spec file
	foreach(INST CellView->instances
		(let (N P Nparam Pparam paraN1 paraN2 paraP1 paraP2 paraP3 paraP4 paraP5 paraP6 paraP7 paraP8 paraP9 paraP10)
		when( (INST->name==parameter1) && (INST->cellName=="gate.INV.0-L1_1-R")
		N=evalstring(parameter3)
		Nparam=N/1000000
		P=evalstring(parameter4)
		Pparam=P/1000000
		when((INST->cellName=="gate.INV.0-L1_1-R") && (INST->name=="R.0")
			NWidth=N)
		when((INST->cellName=="gate.INV.0-L1_1-R") && (INST->name=="R.1")
			PWidth=P)
		when((INST->cellName=="gate.INV.0-L1_1-R") && (INST->name=="L.e")
			LePWidth=P)
		when((INST->cellName=="gate.INV.0-L1_1-R") && (INST->name=="Reset")
			ResPWidth=P)
		dbReplaceProp(INST "NW1" "float" Nparam)
		dbReplaceProp(INST "PW1" "float" Pparam)
		)
		when( (INST->name==parameter1) && (INST->cellName=="gate.NAND5.0-L1_1-R")
		N=evalstring(parameter3)
		Nparam=N/1000000
		P=evalstring(parameter4)
		Pparam=P/1000000
			rvPWidth=P
			rvNWidth=N
		dbReplaceProp(INST "NW5" "float" Nparam)
		dbReplaceProp(INST "PW1" "float" Pparam)
		)
		when( ( (INST->cellName=="stack.NMOS_CHAIN_2.0-L1-R") || (INST->cellName=="stack.PMOS_CHAIN_2.0-L1-R"))
		paraN1 = strcat( parameter1 "." "N1")
		paraN2 = strcat( parameter1 "." "N2")
		paraP1 = strcat( parameter1 "." "P1")
		paraP2 = strcat( parameter1 "." "P2")
		paraP3 = strcat( parameter1 "." "P3")
		paraP4 = strcat( parameter1 "." "P4")
		paraP5 = strcat( parameter1 "." "P5")
		paraP6 = strcat( parameter1 "." "P6")
		paraP7 = strcat( parameter1 "." "P7")
		paraP8 = strcat( parameter1 "." "P8")
		paraP9 = strcat( parameter1 "." "P9")
		paraP10 = strcat( parameter1 "." "P10")
		when(((INST->name==paraN1) || (INST->name==paraP1) || (INST->name==paraN2) || (INST->name==paraP2) || (INST->name==paraP3) || (INST->name==paraP4) || (INST->name==paraP5) || (INST->name==paraP6) || (INST->name==paraP7) || (INST->name==paraP8) || (INST->name==paraP9) || (INST->name==paraP10))
		N=evalstring(parameter3)
		Nparam=N/2000000
		P=evalstring(parameter4)
		Pparam=P/2000000
		dbReplaceProp(INST "NW2" "float" Nparam)
		dbReplaceProp(INST "NW5" "float" Nparam)
		dbReplaceProp(INST "PW2" "float" Pparam)
		dbReplaceProp(INST "PW1" "float" Pparam)
		))
		)))
; Calculates the XY origina and bBox to move instances w.r.t the new spec
	foreach(INST CellView->instances
		(let (cordNx cordNx1 cordNx2 cordPx cordPx1 cordPx2 xy1 xy2 XY bx1 bx2 by1 by2 diff)
		xy1=car(INST~>xy)
		xy2=cadr(INST~>xy)
		bx1=caar(INST~>bBox)
		by1=cadar(INST~>bBox)
		bx2=caadr(INST~>bBox)
		by2=cadadr(INST~>bBox)
		when(((INST->cellName=="stack.NMOS_CHAIN_2.0-L1-R") && (INST->name=="_r.2.N1"))
			cordNx=caar(INST~>bBox)
			cordNx1=cordNx+0.02
			cordnx1=cordNx1
			cordNx2=cordNx1-0.06
			cordnx2=cordNx2)
		when(((INST->cellName=="stack.PMOS_CHAIN_2.0-L1-R") && (INST->name=="_r.2.P1"))
			cordPx=caadr(INST~>bBox)
			Lpinx=caar(INST~>bBox)
			cordPx1=cordPx-0.02
			cordpx1=cordPx1
			cordPx2=cordPx1+0.06
			cordpx2=cordPx2)
		when(((INST->cellName=="gate.INV.0-L1_1-R") && (INST->name=="R.0"))
			cordR0y1=cadar(INST~>bBox)
			cordR0y2=cadadr(INST~>bBox))
		when(((INST->cellName=="gate.INV.0-L1_1-R") && (INST->name=="R.2"))
			cordR2x1=caar(INST~>bBox)
			cordR2x2=caadr(INST~>bBox)
			cordR2y2=cadadr(INST~>bBox))
		when(((INST->cellName=="gate.INV.0-L1_1-R") && (INST->name=="R.1"))
			cordR1x1=caar(INST~>bBox)
			cordR1x2=caadr(INST~>bBox)
			cordR1y2=cadadr(INST~>bBox))
		when(((INST->cellName=="gate.INV.0-L1_1-R") && (INST->name=="Reset"))
		when(ResPWidth>=0.15
			p_contt=0.05
			dbReplaceProp(INST "p_contact_offset" "float" p_contt)
			cordResx2=caadr(INST~>bBox))
		when(ResPWidth<0.15
			p_contt=0.14
			dbReplaceProp(INST "p_contact_offset" "float" p_contt)
			cordResx2=caadr(INST~>bBox)))
		when(((INST->cellName=="gate.INV.0-L1_1-R") && (INST->name=="_Reset"))
			cordresx1=caar(INST~>bBox))
		when(((INST->cellName=="gate.NAND5.0-L1_1-R") && (INST->name=="rv"))
			cordrvx1=caar(INST~>bBox)
			cordrvx2=caadr(INST~>bBox)
			cordrvy2=cadadr(INST~>bBox))
		when(((INST->cellName=="gate.INV.0-L1_1-R") && (INST->name=="L.e"))
			cordLex1=caar(INST~>bBox)
			cordLex2=caadr(INST~>bBox)
			cordLey2=cadadr(INST~>bBox))
		))

	foreach(INST CellView->instances
		(let (xy1 xy2 XY bx1 bx2 by1 by2 diff)
		xy1=car(INST~>xy)
		xy2=cadr(INST~>xy)
		bx1=caar(INST~>bBox)
		by1=cadar(INST~>bBox)
		bx2=caadr(INST~>bBox)
		by2=cadadr(INST~>bBox)
		when((INST->cellName=="gate.INV.0-L1_1-R") && ((INST->name=="R.0")||(INST->name=="R.2"))
		when((cordR0y1==0.69)&&(cordR1x1>(cordnx1-0.27))
		n_contt=(0.975-0.09-(NWidth/2)-(cordnx1-0.43)-0.04)
		dbReplaceProp(INST "n_contact_offset" "float" n_contt))
		when((cordR0y1==0.69)&&(cordR1x1<=(cordnx1-0.27))
		n_contt=(0.975-0.09-(NWidth/2)-(cordR1x1-0.16)-0.04)
		dbReplaceProp(INST "n_contact_offset" "float" n_contt))
		when((cordR0y1!=0.69)&&(cordR1x1>(cordnx1-0.27))
		n_contt=(0.975-0.09-NWidth-(cordnx1-0.43)-0.04)
		dbReplaceProp(INST "n_contact_offset" "float" n_contt))
		when((cordR0y1!=0.69)&&(cordR1x1<=(cordnx1-0.27))
		n_contt=(0.975-0.09-NWidth-(cordR1x1-0.16)-0.04)
		dbReplaceProp(INST "n_contact_offset" "float" n_contt))) ;moves Poly_M1 contacts i.e n_contact_offset on the left side of the R.0/R.2 INV gates
		when((INST->cellName=="gate.INV.0-L1_1-R") && (INST->name=="L.e")
		when((cordLey2==4.25)&&((LePWidth/3)>=0.21)
	;	p_contt=(cordLex2-0.09-(PWidth/3)-0.975-0.195)
		p_contt=0.05
		dbReplaceProp(INST "p_contact_offset" "float" p_contt)
		cordLex3=caadr(INST~>bBox)
		cordLex4=caar(INST~>bBox))
		when((cordLey2==4.12)&&((LePWidth/2)>=0.21)
		p_contt=0.05
		dbReplaceProp(INST "p_contact_offset" "float" p_contt)
		cordLex3=caadr(INST~>bBox)
		cordLex4=caar(INST~>bBox))
		when((cordLey2==3.99)&&(LePWidth>=0.21)
		p_contt=0.05
		dbReplaceProp(INST "p_contact_offset" "float" p_contt)
		cordLex3=caadr(INST~>bBox)
		cordLex4=caar(INST~>bBox))
		when((cordLey2==4.25)&&((LePWidth/3)<0.21)
		p_contt=0.15
		dbReplaceProp(INST "p_contact_offset" "float" p_contt)
		cordLex3=caadr(INST~>bBox)
		cordLex4=caar(INST~>bBox))
		when((cordLey2==4.12)&&((LePWidth/2)<0.21)
		p_contt=0.15
		dbReplaceProp(INST "p_contact_offset" "float" p_contt)
		cordLex3=caadr(INST~>bBox)
		cordLex4=caar(INST~>bBox))
		when((cordLey2==3.99)&&(LePWidth<0.21)
		p_contt=0.15
		dbReplaceProp(INST "p_contact_offset" "float" p_contt)
		cordLex3=caadr(INST~>bBox)
		cordLex4=caar(INST~>bBox))) ;moves Poly_M1 contacts i.e p_contact_offset on the right side of the L.e INV gate
		when((INST->cellName=="gate.INV.0-L1_1-R") && ((INST->name=="R.1")||(INST->name=="R.3"))
		when((cordR1y2==1.39)&&(cordR2x2<(cordpx1+0.27))
		p_contt=((cordpx1+0.56)-0.975-0.09-0.04-(PWidth/2))
		dbReplaceProp(INST "p_contact_offset" "float" p_contt)
		cordR1x3=caadr(INST~>bBox))
		when((cordR1y2==1.39)&&(cordR2x2>=(cordpx1+0.27))
		p_contt=((cordR2x2+0.26)-0.975-0.09-0.04-(PWidth/2))
		dbReplaceProp(INST "p_contact_offset" "float" p_contt)
		cordR1x3=caadr(INST~>bBox))
		when((cordR1y2!=1.39)&&(cordR2x2<(cordpx1+0.27))
		p_contt=((cordpx1+0.56)-0.975-0.09-0.04-PWidth)
		dbReplaceProp(INST "p_contact_offset" "float" p_contt)
		cordR1x3=caadr(INST~>bBox))
		when((cordR1y2!=1.39)&&(cordR2x2>=(cordpx1+0.27))
		p_contt=((cordR2x2+0.26)-0.975-0.09-0.04-PWidth)
		dbReplaceProp(INST "p_contact_offset" "float" p_contt)
		cordR1x3=caadr(INST~>bBox)));moves Poly_M1 contacts i.e p_contact_offset on the right side of the R.1/R.3 INV gates
		when((INST->cellName=="stack.PMOS_CHAIN_1.0-L1-R") && (((xy2==5.72)&&(xy1==1.46))||((xy2==4.55)&&(xy1==1.46))||((xy2==1.69)&&(xy1==1.46))||((xy2==0.52)&&(xy1==1.46)))
		XY=((cordpx1+0.01):xy2)
		dbSet(INST XY "xy")) ; moves PMOs chains on the right side of the C2 gate w.r.t the new spec file
		when((INST->cellName=="stack.NMOS_CHAIN_1.0-L1-R") && (((xy2==5.59)&&(xy1==0.62))||((xy2==4.42)&&(xy1==0.62))||((xy2==1.56)&&(xy1==0.62))||((xy2==0.39)&&(xy1==0.62)))
		XY=((cordnx1-0.01):xy2)
		dbSet(INST XY "xy")) ; moves NMOS chains on the left side of the C2 gate w.r.t the new spec file
		when((INST~>cellName=="M1_POLYmin")&&(((xy2==5.915)&&(xy1==1.74))||((xy2==5.655)&&(xy1==1.74))||((xy2==4.745)&&(xy1==1.74))||((xy2==4.485)&&(xy1==1.74))||((xy2==1.885)&&(xy1==1.74))||((xy2==1.625)&&(xy1==1.74))||((xy2==0.715)&&(xy1==1.74))||((xy2==0.455)&&(xy1==1.74)))
		when((cordR2x2<(cordpx1+0.27))
		XY=(cordpx1+0.29:xy2))
		when((cordR2x2>=(cordpx1+0.27))
		XY=(cordR2x2+0.02:xy2))
		dbSet(INST XY "xy")) ;moves M1_poly vias on the right side of C2 gates
		when((INST~>cellName=="M1_POLYmin")&&(((xy2==5.785)&&(xy1==0.34))||((xy2==5.525)&&(xy1==0.34))||((xy2==4.615)&&(xy1==0.34))||((xy2==4.355)&&(xy1==0.34))||((xy2==1.755)&&(xy1==0.34))||((xy2==1.495)&&(xy1==0.34))||((xy2==0.585)&&(xy1==0.34))||((xy2==0.325)&&(xy1==0.34)))
		when((cordR1x1>(cordnx1-0.27))
		XY=(cordnx1-0.29:xy2))
		when((cordR1x1<=(cordnx1-0.27))
		XY=(cordR1x1-0.02:xy2))
		dbSet(INST XY "xy")) ;moves M1_poly vias on the left side of C2 gates
		when((INST~>cellName=="M1_POLYmin")&&(((xy2==5.785)&&(xy1==1.88))||((xy2==4.615)&&(xy1==1.88))||((xy2==1.755)&&(xy1==1.88))||((xy2==0.585)&&(xy1==1.88)))
		when((cordR2x2<(cordpx1+0.27))
		XY=(cordpx1+0.43:xy2))
		when((cordR2x2>=(cordpx1+0.27))
		XY=(cordR2x2+0.16:xy2))
		dbSet(INST XY "xy")) ;moves M1_poly vias on the right side of the PMOS chain of C2 gates
		when((INST~>cellName=="M1_POLYmin")&&(((xy2==5.655)&&(xy1==0.2))||((xy2==4.485)&&(xy1==0.2))||((xy2==1.625)&&(xy1==0.2))||((xy2==0.455)&&(xy1==0.2)))
		when((cordR1x1>(cordnx1-0.27))
		XY=(cordnx1-0.43:xy2))
		when((cordR1x1<=(cordnx1-0.27))
		XY=(cordR1x1-0.16:xy2))
		ActualLeftPoly=car(XY)
		dbSet(INST XY "xy")) ;moves M1_poly vias on the left sideof the NMOS chain of C2 gates
		when((INST->cellName=="gate.INV.0-L1_1-R")&&(INST->name=="R.2")
		when(cordR2y2==5.29
		pnts=(1.17:5.2)
		        dbCreateParamInstByMasterName(CellView "tsmc28" "M2_M1_2cut_p1_2" "layout" nil pnts "R0" 1
	               list( list("column" "int" 1)
                     list("row" "int" 1)
                     list("layer1YEnclosure" "float" 0.005)
                     list("layer1XEnclosure" "float" 0.04)
                     list("layer2YEnclosure" "float" 0.03)
                     list("layer2XEnclosure" "float" 0.015) ) ))
		when(cordR2y2==5.29
		pnts=(0.78:5.2)
		        dbCreateParamInstByMasterName(CellView "tsmc28" "M2_M1_2cut_p1_2" "layout" nil pnts "R0" 1
	               list( list("column" "int" 1)
                     list("row" "int" 1)
                     list("layer1YEnclosure" "float" 0.005)
                     list("layer1XEnclosure" "float" 0.04)
                     list("layer2YEnclosure" "float" 0.03)
                     list("layer2XEnclosure" "float" 0.015) ) )))

		when((INST->cellName=="gate.INV.0-L1_1-R")&&(INST->name=="R.1")
		when(cordR1y2==1.39
		pnts=(0.78:1.3)
		        dbCreateParamInstByMasterName(CellView "tsmc28" "M2_M1_2cut_p1_2" "layout" nil pnts "R0" 1
	               list( list("column" "int" 1)
                     list("row" "int" 1)
                     list("layer1YEnclosure" "float" 0.005)
                     list("layer1XEnclosure" "float" 0.04)
                     list("layer2YEnclosure" "float" 0.03)
                     list("layer2XEnclosure" "float" 0.015) ) ))
		when(cordR1y2==1.39
		pnts=(1.17:1.3)
		        dbCreateParamInstByMasterName(CellView "tsmc28" "M2_M1_2cut_p1_2" "layout" nil pnts "R0" 1
	               list( list("column" "int" 1)
                     list("row" "int" 1)
                     list("layer1YEnclosure" "float" 0.005)
                     list("layer1XEnclosure" "float" 0.04)
                     list("layer2YEnclosure" "float" 0.03)
                     list("layer2XEnclosure" "float" 0.015) ) )))

		))

	foreach(INST CellView->instances
		(let (xy1 xy2 XY bx1 bx2 by1 by2 diff)
		xy1=car(INST~>xy)
		xy2=cadr(INST~>xy)
		bx1=caar(INST~>bBox)
		by1=cadar(INST~>bBox)
		bx2=caadr(INST~>bBox)
		by2=cadadr(INST~>bBox)
		when((INST->cellName=="gate.NAND5.0-L1_1-R") && (INST->name=="rv")
		when((cordrvy2==3.86)&&((rvPWidth/2)<=cordLex3)&&((rvPWidth/2)>=0.21)
		p_contt=(cordLex3-0.975-0.09-(rvPWidth/2)-0.1)
		dbReplaceProp(INST "p_contact_offset" "float" p_contt)
		cordrvx3=caadr(INST~>bBox)
		cordrvx4=caar(INST~>bBox))
		when((cordrvy2==3.21)&&(rvPWidth<=cordLex3)&&(rvPWidth>=0.21)
		p_contt=(cordLex3-0.975-0.09-rvPWidth-0.1)
		dbReplaceProp(INST "p_contact_offset" "float" p_contt)
		cordrvx3=caadr(INST~>bBox)
		cordrvx4=caar(INST~>bBox))
		when((cordrvy2==3.86)&&((rvPWidth/2)>cordLex3)&&((rvPWidth/2)>=0.21)
		p_contt=0.06
		dbReplaceProp(INST "p_contact_offset" "float" p_contt)
		cordrvx3=caadr(INST~>bBox)
		cordrvx4=caar(INST~>bBox))
		when((cordrvy2==3.21)&&(rvPWidth>cordLex3)&&(rvPWidth>=0.21)
		p_contt=0.06
		dbReplaceProp(INST "p_contact_offset" "float" p_contt)
		cordrvx3=caadr(INST~>bBox)
		cordrvx4=caar(INST~>bBox))
		when((cordrvy2==3.86)&&((rvPWidth/2)<0.21)&&((rvPWidth/2)<=cordLex3)
		p_contt=(cordLex3-0.975-0.09-(rvPWidth/2)-0.1)
		dbReplaceProp(INST "p_contact_offset" "float" p_contt)
		cordrvx3=caadr(INST~>bBox)
		cordrvx4=caar(INST~>bBox))
		when((cordrvy2==3.86)&&((rvPWidth/2)<0.21)&&((rvPWidth/2)>cordLex3)
		p_contt=0.15
		dbReplaceProp(INST "p_contact_offset" "float" p_contt)
		cordrvx3=caadr(INST~>bBox)
		cordrvx4=caar(INST~>bBox))
		when((cordrvy2==3.21)&&(rvPWidth<0.21)&&(rvPWidth<=cordLex3)
		p_contt=(cordLex3-0.975-0.09-rvPWidth-0.1)
		dbReplaceProp(INST "p_contact_offset" "float" p_contt)
		cordrvx3=caadr(INST~>bBox)
		cordrvx4=caar(INST~>bBox))
		when((cordrvy2==3.21)&&(rvPWidth<0.21)&&(rvPWidth>cordLex3)
		p_contt=0.15
		dbReplaceProp(INST "p_contact_offset" "float" p_contt)
		cordrvx3=caadr(INST~>bBox)
		cordrvx4=caar(INST~>bBox))) ; moves Poly_M1 contacts i.e p_contact_offset on the right side of the L.e NAND5 gate

	))

	foreach(INST CellView->instances
		(let (xy1 xy2 XY bx1 bx2 by1 by2 diff)
		xy1=car(INST~>xy)
		xy2=cadr(INST~>xy)
		bx1=caar(INST~>bBox)
		by1=cadar(INST~>bBox)
		bx2=caadr(INST~>bBox)
		by2=cadadr(INST~>bBox)
		when((INST->cellName=="stack.PPLUG.0")&&(xy1==1.925&&xy2==2.355)
		when(((cordrvx3>=cordLex3)&&(cordrvx3>=cordR1x3))
		XY=((cordrvx3-0.115):xy2))
		when(((cordLex3>cordrvx3)&&(cordLex3>=cordR1x3))
		XY=((cordLex3-0.115):xy2))
		when(((cordR1x3>cordrvx3)&&(cordR1x3>cordLex3))
		XY=((cordR1x3-0.115):xy2))
		dbSet(INST XY "xy")) ; moves PPLUG
		when((INST->cellName=="stack.NPLUG.0")&&(xy1==0.155&&xy2==2.38)
		when(((cordrvx4<=cordLex4)&&(cordrvx4<=(cordnx1-0.5)))&&(cordR1x1>(cordnx1-0.27))
		XY=((cordrvx4+0.115):xy2))
		when(((cordrvx4<=cordLex4)&&(cordrvx4<=(cordnx1-0.5)))&&(cordR1x1<=(cordnx1-0.27))
		XY=((cordR1x1-0.115):xy2))
		when(((cordLex4<cordrvx4)&&(cordLex4<=(cordnx1-0.5)))&&(cordR1x1>(cordnx1-0.27))
		XY=((cordLex4+0.115):xy2))
		when(((cordLex4<cordrvx4)&&(cordLex4<=(cordnx1-0.5)))&&(cordR1x1<=(cordnx1-0.27))
		XY=((cordR1x1-0.115):xy2))
		when((((cordnx1-0.5)<cordLex4)&&((cordnx1-0.5)<=cordrvx4))&&(cordR1x1>(cordnx1-0.27))
		XY=((cordnx1-0.385):xy2))
		when((((cordnx1-0.5)<cordLex4)&&((cordnx1-0.5)<=cordrvx4))&&(cordR1x1<=(cordnx1-0.27))
		XY=((cordR1x1-0.115):xy2))
		dbSet(INST XY "xy")) ; moves NPLUG

	))

	foreach(SHAPE CellView->shapes
		(let (bx1 bx2 by1 by2 x1 x2 x3 x4 x5 x6 x7 x8 y1 y2 y3 y4 y5 y6 y7 y8 xy1 xy2 pnts bbox orgn)
		bx1=caar(SHAPE~>bBox)
		by1=cadar(SHAPE~>bBox)
		bx2=caadr(SHAPE~>bBox)
		by2=cadadr(SHAPE~>bBox)
		xy1=car(SHAPE~>xy)
		xy2=cadr(SHAPE~>xy)
		x1=caar(SHAPE~>points)
		y1=cadar(SHAPE~>points)
		x2=caadr(SHAPE~>points)
		y2=cadadr(SHAPE~>points)
		x3=caaddr(SHAPE~>points)
		y3=car(cdaddr(SHAPE~>points))
		x4=car(cadddr(SHAPE~>points))
		y4=cadr(cadddr(SHAPE~>points))
		x5=caar(cddddr(SHAPE~>points))
		y5=cadar(cddddr(SHAPE~>points))
		x6=caadr(cddddr(SHAPE~>points))
		y6=cadadr(cddddr(SHAPE~>points))
		x7=caaddr(cddddr(SHAPE~>points))
		y7=car(cdaddr(cddddr(SHAPE~>points)))
		x8=car(cadddr(cddddr(SHAPE~>points)))
		y8=cadr(cadddr(cddddr(SHAPE~>points)))
		when((SHAPE~>layerName=="PO")&&(((bx1==0.91)&&(by1==5.9))||((bx1==0.935)&&(by1==5.64))||((bx1==0.93)&&(by1==4.73))||((bx1==0.93)&&(by1==4.47))||((bx1==0.91)&&(by1==1.87))||((bx1==0.92)&&(by1==1.61))||((bx1==0.895)&&(by1==0.7))||((bx1==0.875)&&(by1==0.44)))
		when((cordR2x2<(cordpx1+0.27))
		bbox=list(bx1:by1 (cordpx1+0.29):by2))
		when((cordR2x2>=(cordpx1+0.27))
		bbox=list(bx1:by1 (cordR2x2+0.02):by2))
		dbSet(SHAPE bbox "bBox")); moves poly on the right side of c2 gates i.e connecting R.e net
		when((SHAPE~>layerName=="PO")&&(((bx1==0.975)&&(by1==5.77))||((bx1==0.975)&&(by1==4.6))||((bx1==0.975)&&(by1==1.74))||((bx1==0.975)&&(by1==0.57)))
		when((cordR2x2<(cordpx1+0.27))
		bbox=list(bx1:by1 (cordpx1+0.43):by2))
		when((cordR2x2>=(cordpx1+0.27))
		bbox=list(bx1:by1 (cordR2x2+0.16):by2))
		dbSet(SHAPE bbox "bBox")); moves poly on the right side of PMOS gate of c2 gates
		when((SHAPE~>layerName=="PO")&&(((bx1==0.325)&&(by1==5.77))||((bx1==0.325)&&(by1==5.51))||((bx1==0.325)&&(by1==4.6))||((bx1==0.325)&&(by1==4.34))||((bx1==0.325)&&(by1==1.74))||((bx1==0.325)&&(by1==1.48))||((bx1==0.325)&&(by1==0.57))||((bx1==0.325)&&(by1==0.31)))
		when((cordR1x1>(cordnx1-0.27))
		bbox=list((cordnx1-0.29):by1 bx2:by2))
		when((cordR1x1<=(cordnx1-0.27))
		bbox=list((cordR1x1-0.02):by1 bx2:by2))
		dbSet(SHAPE bbox "bBox")); moves poly on the left side of c2 gates i.e connecting L.3/L.2/L.1/L.0 net
		when((SHAPE~>layerName=="PO")&&(((bx1==0.225)&&(by1==5.64))||((bx1==0.215)&&(by1==4.47))||((bx1==0.22)&&(by1==1.61))||((bx1==0.22)&&(by1==0.44)))
		when((cordR1x1>(cordnx1-0.27))
		bbox=list((cordnx1-0.43):by1 bx2:by2))
		when((cordR1x1<=(cordnx1-0.27))
		bbox=list((cordR1x1-0.16):by1 bx2:by2))
		dbSet(SHAPE bbox "bBox")); moves poly on the left side of NMOS gate of c2 gates
		when((SHAPE~>layerName=="PO")&&(((by1==5.71)&&(by2==5.86))||((by1==4.54)&&(by2==4.69))||((by1==1.68)&&(by2==1.83))||((by1==0.51)&&(by2==0.66)))
		bbox=list((cordpx1-0.025):by1 (cordpx1+0.055):by2)
		dbSet(SHAPE bbox "bBox")); moves Cut_Poly on the right side of c2 gates
		when((SHAPE~>layerName=="PO")&&(((by1==5.58)&&(by2==5.73))||((by1==4.41)&&(by2==4.56))||((by1==1.55)&&(by2==1.7))||((by1==0.38)&&(by2==0.53)))
		bbox=list((cordnx1+0.025):by1 (cordnx1-0.055):by2)
		dbSet(SHAPE bbox "bBox")); moves Cut_Poly on the left side of c2 gates
		when((SHAPE~>layerName=="M1")&&(((bx1==1.065)&&(by1==5.82))||((bx1==1.065)&&(by1==5.56))||((bx1==1.065)&&(by1==4.65))||((bx1==1.065)&&(by1==4.39))||((bx1==1.065)&&(by1==1.79))||((bx1==1.065)&&(by1==1.53))||((bx1==1.065)&&(by1==0.62))||((bx1==1.065)&&(by1==0.36)))
		bbox=list(bx1:by1 (cordpx1+0.15):by2)
		dbSet(SHAPE bbox "bBox")); moves horizontal M1 connecting the PMOS chains on the right side of C2 gates
		when((SHAPE~>layerName=="M1")&&(((bx1==1.54)&&(by1==5.56))||((bx1==1.54)&&(by1==4.39))||((bx1==1.54)&&(by1==1.53))||((bx1==1.54)&&(by1==0.36)))
		bbox=list((cordpx1+0.09):by1 (cordpx1+0.15):by2)
		dbSet(SHAPE bbox "bBox")); moves vertical M1 connecting the PMOS chains on the right side of C2 gates
		when((SHAPE~>layerName=="M1")&&(((bx1==0.48)&&(by1==5.82))||((bx1==0.48)&&(by1==5.56))||((bx1==0.48)&&(by1==4.65))||((bx1==0.48)&&(by1==4.39))||((bx1==0.48)&&(by1==1.79))||((bx1==0.48)&&(by1==1.53))||((bx1==0.48)&&(by1==0.62))||((bx1==0.48)&&(by1==0.36)))
		bbox=list((cordnx1-0.15):by1 bx2:by2)
		dbSet(SHAPE bbox "bBox")); moves horizontal M1 connecting the NMOS chains on the left side of C2 gates
		when((SHAPE~>layerName=="M1")&&(((bx1==0.48)&&(by1==5.69))||((bx1==0.48)&&(by1==4.52))||((bx1==0.48)&&(by1==1.66))||((bx1==0.48)&&(by1==0.49)))
		bbox=list((cordnx1-0.15):by1 (cordnx1-0.09):by2)
		dbSet(SHAPE bbox "bBox")); moves vertical M1 connecting the NMOS chains on the left side of C2 gates
		when((SHAPE~>layerName=="M1")&&(((by1==5.625)&&(by2==5.945))||((by1==4.455)&&(by2==4.775))||((by1==1.595)&&(by2==1.915))||((by1==0.425)&&(by2==0.745)))
		when((cordR2x2<(cordpx1+0.27))
		bbox=list((cordpx1+0.25):by1 (cordpx1+0.33):by2))
		when((cordR2x2>=(cordpx1+0.27))
		bbox=list((cordR2x2-0.02):by1 (cordR2x2+0.06):by2))
		dbSet(SHAPE bbox "bBox")); moves vertical M1 connecting the R.e input on the right side of C2 gates i.e connecting the 2 poly_M1 vias
		when((SHAPE~>layerName=="M1")&&(((by1==5.495)&&(by2==5.815))||((by1==4.325)&&(by2==4.645))||((by1==1.465)&&(by2==1.785))||((by1==0.295)&&(by2==0.615)))
		when((cordR1x1>(cordnx1-0.27))
		bbox=list((cordnx1-0.25):by1 (cordnx1-0.33):by2))
		when((cordR1x1<=(cordnx1-0.27))
		bbox=list((cordR1x1-0.06):by1 (cordR1x1+0.02):by2))
		dbSet(SHAPE bbox "bBox")); moves vertical M1 connecting the L.0/L.1/L.2/L.3 input on the left side of C2 gates i.e connecting the 2 poly_M1 vias
		when((SHAPE~>layerName=="M1")&&(SHAPE~>net~>name=="R.3")
		when((cordR2x2<(cordpx1+0.27))&&(cordR1x1>(cordnx1-0.27))
		pnts=list((cordnx1-0.43):y1 (cordnx1-0.43):y2 (cordpx1+0.24):y3 (cordpx1+0.24):y4 (cordpx1+0.43):y5 (cordpx1+0.43):y6))
		when((cordR2x2<(cordpx1+0.27))&&(cordR1x1<=(cordnx1-0.27))
		pnts=list((cordR1x1-0.16):y1 (cordR1x1-0.16):y2 (cordpx1+0.24):y3 (cordpx1+0.24):y4 (cordpx1+0.43):y5 (cordpx1+0.43):y6))
		when((cordR2x2>=(cordpx1+0.27))&&(cordR1x1>(cordnx1-0.27))
		pnts=list((cordnx1-0.43):y1 (cordnx1-0.43):y2 (cordR2x2+0.015):y3 (cordR2x2+0.015):y4 (cordR2x2+0.16):y5 (cordR2x2+0.16):y6))
		when((cordR2x2>=(cordpx1+0.27))&&(cordR1x1<=(cordnx1-0.27))
		pnts=list((cordR1x1-0.16):y1 (cordR1x1-0.16):y2 (cordR2x2+0.015):y3 (cordR2x2+0.015):y4 (cordR2x2+0.16):y5 (cordR2x2+0.16):y6))
		dbSet(SHAPE pnts "points")); moves vertical M1 connecting the R.3 input on M1 going through the R.3 INV
		when((SHAPE~>layerName=="M1")&&(SHAPE~>net~>name=="R.2")
		when((cordR2x2<(cordpx1+0.27))&&(cordR1x1>(cordnx1-0.27))
		pnts=list((cordpx1+0.43):y1 (cordpx1+0.43):y2 (cordnx1-0.24):y3 (cordnx1-0.24):y4 (cordnx1-0.43):y5 (cordnx1-0.43):y6))
		when((cordR2x2<(cordpx1+0.27))&&(cordR1x1<=(cordnx1-0.27))
		pnts=list((cordpx1+0.43):y1 (cordpx1+0.43):y2 (cordR1x1-0.015):y3 (cordR1x1-0.015):y4 (cordR1x1-0.16):y5 (cordR1x1-0.16):y6))
		when((cordR2x2>=(cordpx1+0.27))&&(cordR1x1>(cordnx1-0.27))
		pnts=list((cordR2x2+0.16):y1 (cordR2x2+0.16):y2 (cordnx1-0.24):y3 (cordnx1-0.24):y4 (cordnx1-0.43):y5 (cordnx1-0.43):y6))
		when((cordR2x2>=(cordpx1+0.27))&&(cordR1x1<=(cordnx1-0.27))
		pnts=list((cordR2x2+0.16):y1 (cordR2x2+0.16):y2 (cordR1x1-0.015):y3 (cordR1x1-0.015):y4 (cordR1x1-0.16):y5 (cordR1x1-0.16):y6))
		dbSet(SHAPE pnts "points")); moves vertical M1 connecting the R.2 input on M1 going through the R.2 INV
		when((SHAPE~>layerName=="M1")&&(SHAPE~>net~>name=="R.1")
		when((cordR2x2<(cordpx1+0.27))&&(cordR1x1>(cordnx1-0.27))
		pnts=list((cordnx1-0.43):y1 (cordnx1-0.43):y2 (cordpx1+0.24):y3 (cordpx1+0.24):y4 (cordpx1+0.43):y5 (cordpx1+0.43):y6))
		when((cordR2x2<(cordpx1+0.27))&&(cordR1x1<=(cordnx1-0.27))
		pnts=list((cordR1x1-0.16):y1 (cordR1x1-0.16):y2 (cordpx1+0.24):y3 (cordpx1+0.24):y4 (cordpx1+0.43):y5 (cordpx1+0.43):y6))
		when((cordR2x2>=(cordpx1+0.27))&&(cordR1x1>(cordnx1-0.27))
		pnts=list((cordnx1-0.43):y1 (cordnx1-0.43):y2 (cordR2x2+0.015):y3 (cordR2x2+0.015):y4 (cordR2x2+0.16):y5 (cordR2x2+0.16):y6))
		when((cordR2x2>=(cordpx1+0.27))&&(cordR1x1<=(cordnx1-0.27))
		pnts=list((cordR1x1-0.16):y1 (cordR1x1-0.16):y2 (cordR2x2+0.015):y3 (cordR2x2+0.015):y4 (cordR2x2+0.16):y5 (cordR2x2+0.16):y6))
		dbSet(SHAPE pnts "points")); moves vertical M1 connecting the R.1 input on M1 going through the R.1 INV
		when((SHAPE~>layerName=="M1")&&(SHAPE~>net~>name=="R.0")
		when((cordR2x2<(cordpx1+0.27))&&(cordR1x1>(cordnx1-0.27))
		pnts=list((cordnx1-0.43):y1 (cordnx1-0.43):y2 (cordnx1-0.24):y3 (cordnx1-0.24):y4 (cordpx1+0.43):y5 (cordpx1+0.43):y6))
		when((cordR2x2<(cordpx1+0.27))&&(cordR1x1<=(cordnx1-0.27))
		pnts=list((cordR1x1-0.16):y1 (cordR1x1-0.16):y2 (cordR1x1-0.015):y3 (cordR1x1-0.015):y4 (cordpx1+0.43):y5 (cordpx1+0.43):y6))
		when((cordR2x2>=(cordpx1+0.27))&&(cordR1x1>(cordnx1-0.27))
		pnts=list((cordnx1-0.43):y1 (cordnx1-0.43):y2 (cordnx1-0.24):y3 (cordnx1-0.24):y4 (cordR2x2+0.16):y5 (cordR2x2+0.16):y6))
		when((cordR2x2>=(cordpx1+0.27))&&(cordR1x1<=(cordnx1-0.27))
		pnts=list((cordR1x1-0.16):y1 (cordR1x1-0.16):y2 (cordR1x1-0.015):y3 (cordR1x1-0.015):y4 (cordR2x2+0.16):y5 (cordR2x2+0.16):y6))
		dbSet(SHAPE pnts "points")); moves vertical M1 connecting the R.0 input on M1 going through the R.0 INV
		when((SHAPE~>layerName=="M1")&&((SHAPE~>net~>name=="_r.3")||(SHAPE~>net~>name=="_r.1"))&&(((bx1==1.39)&&(by1==5.365))||((bx1==1.395)&&(by1==0.11)))
		when((cordR2x2<(cordpx1+0.27))
		pnts=list((Lpinx+0.35):y1 (cordpx1+0.56):y2 (cordpx1+0.56):y3 ))
		when((cordR2x2>=(cordpx1+0.27))
		pnts=list((Lpinx+0.35):y1 (cordR2x2+0.285):y2 (cordR2x2+0.285):y3 ))
		dbSet(SHAPE pnts "points")); moves M1 connecting the _r.3/_r.1 with poly_M1 vias of the R.3 INV
		when((SHAPE~>layerName=="M1")&&(bx1==0.125)&&(by1==2.185)
		when(((cordrvx4<=cordLex4)&&(cordrvx4<=(cordnx1-0.5)))&&(cordR1x1>(cordnx1-0.27))
		pnts=list(x1:y1 (cordrvx4+0.115):y2 (cordrvx4+0.115):y3 ))
		when(((cordrvx4<=cordLex4)&&(cordrvx4<=(cordnx1-0.5)))&&(cordR1x1<=(cordnx1-0.27))
		pnts=list(x1:y1 (cordR1x1-0.115):y2 (cordR1x1-0.115):y3 ))
		when(((cordLex4<cordrvx4)&&(cordLex4<=(cordnx1-0.5)))&&(cordR1x1>(cordnx1-0.27))
		pnts=list(x1:y1 (cordLex4+0.115):y2 (cordLex4+0.115):y3 ))
		when(((cordLex4<cordrvx4)&&(cordLex4<=(cordnx1-0.5)))&&(cordR1x1<=(cordnx1-0.27))
		pnts=list(x1:y1 (cordR1x1-0.115):y2 (cordR1x1-0.115):y3 ))
		when((((cordnx1-0.5)<cordLex4)&&((cordnx1-0.5)<=cordrvx4))&&(cordR1x1>(cordnx1-0.27))
		pnts=list(x1:y1 (cordnx1-0.385):y2 (cordnx1-0.385):y3 ))
		when((((cordnx1-0.5)<cordLex4)&&((cordnx1-0.5)<=cordrvx4))&&(cordR1x1<=(cordnx1-0.27))
		pnts=list(x1:y1 (cordR1x1-0.115):y2 (cordR1x1-0.115):y3 ))
		dbSet(SHAPE pnts "points")) ;moves M1 connecting the NPLUG to GND
		when((SHAPE~>layerName=="M1")&&(bx1==1.485)&&(by1==1.995)
		when(((cordrvx3>=cordLex3)&&(cordrvx3>=cordR1x3))
		pnts=list((cordpx1+0.16):y1 (cordrvx3-0.115):y2 (cordrvx3-0.115):y3))
		when(((cordLex3>cordrvx3)&&(cordLex3>=cordR1x3))
		pnts=list((cordpx1+0.16):y1 (cordLex3-0.115):y2 (cordLex3-0.115):y3))
		when(((cordR1x3>cordrvx3)&&(cordR1x3>cordLex3))
		pnts=list((cordpx1+0.16):y1 (cordR1x3-0.115):y2 (cordR1x3-0.115):y3))
		dbSet(SHAPE pnts "points")) ;moves M1 connecting the PPLUG to Vdd
		when((SHAPE~>layerName=="M1")&&(by2==2.055)&&(by1==1.92)
		pnts=list(x1:y1 (cordpx1+0.16):y2 (cordpx1+0.16):y3)
		dbSet(SHAPE pnts "points")) ;moves M1 connecting the PPLUG to Vdd
		when((SHAPE~>layerName=="M2")&&((SHAPE~>net~>name=="_r.3")||(SHAPE~>net~>name=="_r.1"))&&(((bx1==1.36)&&(by1==5.72))||((bx1==1.365)&&(by1==0.13)))
		pnts=list((Lpinx+0.38):y1 (Lpinx+0.38):y2 )
		dbSet(SHAPE pnts "points")); moves M2 connecting the _r.3/_r.1 with poly_M1 vias of the R.3 INV
		when((SHAPE~>layerName=="M2")&&(SHAPE~>net~>name=="_r.3")&&(bx1==1.98)&&(by1==4.28)
		when((cordR2x2<(cordpx1+0.27))
		pnts=list((cordpx1+0.56):y1 (cordpx1+0.56):y2 ))
		when((cordR2x2>=(cordpx1+0.27))
		pnts=list((cordR2x2+0.285):y1 (cordR2x2+0.285):y2 ))
		dbSet(SHAPE pnts "points")); moves M2 connecting the _r.3 with poly_M1 vias of the NAND5 gate
		when((SHAPE~>layerName=="M2")&&(SHAPE~>net~>name=="_r.1")&&(bx1==1.98)&&(by1==0.13)
		when((cordR2x2<(cordpx1+0.27))&&((cordR2x2+0.285)>=(cordrvx3-0.24))
		pnts=list((cordpx1+0.56):y1 (cordpx1+0.56):y2 ))
		when((cordR2x2<(cordpx1+0.27))&&((cordR2x2+0.285)<(cordrvx3-0.24))
		pnts=list((cordpx1+0.56):(y1+0.65) (cordpx1+0.56):(y2+0.65)))
		when((cordR2x2>=(cordpx1+0.27))&&((cordR2x2+0.285)>=(cordrvx3-0.24))
		pnts=list((cordR2x2+0.285):y1 (cordR2x2+0.285):y2 ))
		when((cordR2x2>=(cordpx1+0.27))&&((cordR2x2+0.285)<(cordrvx3-0.24))
		pnts=list((cordR2x2+0.285):(y1+0.65) (cordR2x2+0.285):(y2+0.65)))
		dbSet(SHAPE pnts "points")); moves M2 connecting the _r.1 with poly_M1 vias of the NAND5 gate
		when((SHAPE~>layerName=="M2")&&((SHAPE~>net~>name=="R.2")||(SHAPE~>net~>name=="R.1")||(SHAPE~>net~>name=="R.0"))&&(((bx1==1.85)&&(by1==4.48))||((bx1==1.85)&&(by1==1.34))||((bx1==1.85)&&(by1==0.32)))
		when((cordR2x2<(cordpx1+0.27))
		pnts=list((cordpx1+0.43):y1 (cordpx1+0.43):y2 ))
		when((cordR2x2>=(cordpx1+0.27))
		pnts=list((cordR2x2+0.155):y1 (cordR2x2+0.155):y2 ))
		dbSet(SHAPE pnts "points")); moves M2 connecting the R.2/R.1/R.0 with the respective M3 pins
		when((SHAPE~>layerName=="M2")&&(SHAPE~>net~>name=="R.e")&&(bx1==1.72)&&(by1==0.425)
		when((cordR2x2<(cordpx1+0.27))
		pnts=list((cordpx1+0.3):y1 (cordpx1+0.3):y2 ))
		when((cordR2x2>=(cordpx1+0.27))
		pnts=list((cordR2x2+0.025):y1 (cordR2x2+0.025):y2 ))
		dbSet(SHAPE pnts "points")); moves M2 connecting the R.e with the respective M3 pins
		when((SHAPE~>layerName=="M2")&&(SHAPE~>net~>name=="R.3")&&(bx1==1.6)&&(by2==5.38)
		when((cordR2x2<(cordpx1+0.27))
		pnts=list((cordpx1+0.17):y1 (cordpx1+0.17):y2 ))
		when((cordR2x2>=(cordpx1+0.27))
		pnts=list((cordR2x2-0.105):y1 (cordR2x2-0.105):y2 ))
		dbSet(SHAPE pnts "points")); moves M2 connecting the R.3/_r.1 with the respective M3 pins
		when((SHAPE~>layerName=="M2")&&(SHAPE~>net~>name=="_RESET")&&(bx1==1.415)&&(by1==2.145)
		when((cordR2x2<(cordpx1+0.27))
		pnts=list((cordpx1+0.04):y1 (cordpx1+0.04):y2 ))
		when((cordR2x2>=(cordpx1+0.27))
		pnts=list((cordR2x2-0.235):y1 (cordR2x2-0.235):y2 ))
		dbSet(SHAPE pnts "points")); moves M2 connecting the _RESET with the respective M3 pins
		when((SHAPE~>layerName=="M2")&&((SHAPE~>net~>name=="L.3")||(SHAPE~>net~>name=="L.2")||(SHAPE~>net~>name=="L.1")||(SHAPE~>net~>name=="L.0"))&&(((bx1==0.3)&&(by1==4.95))||((bx1==0.3)&&(by1==4.325))||((bx1==0.3)&&(by1==1.465))||((bx1==0.3)&&(by1==0.27)))
		when((cordR1x1>(cordnx1-0.27))
		pnts=list((cordnx1-0.29):y1 (cordnx1-0.29):y2 ))
		when((cordR1x1<=(cordnx1-0.27))
		pnts=list((cordR1x1-0.02):y1 (cordR1x1-0.02):y2 ))
		dbSet(SHAPE pnts "points")); moves M2 connecting the L.3/L.2/L.1/L.0 with the respective M3 pins
		when((SHAPE~>layerName=="M2")&&(SHAPE~>net~>name=="_r.2")&&(bx1==0.15)&&(by1==3.545)
		when((cordR1x1>(cordnx1-0.27))
		pnts=list((cordnx1-0.43):y1 (cordnx1-0.43):y2 ))
		when((cordR1x1<=(cordnx1-0.27))
		pnts=list((cordR1x1-0.16):y1 (cordR1x1-0.16):y2 ))
		dbSet(SHAPE pnts "points")); moves M2 connecting the _r.2 connecting the Poly_M1 inputs of the INV gate and the NAND5 gate
		when((SHAPE~>layerName=="M2")&&(SHAPE~>net~>name=="_r.0")&&(bx1==0.43)&&(by1==0.145)
		pnts=list((cordnx1-0.16):y1 (cordnx1-0.16):y2 )
		dbSet(SHAPE pnts "points")); moves M2 connecting the _r.0 connecting the Poly_M1 inputs of the INV gate and the NAND5 gate
		when((SHAPE~>layerName=="M1")&&(SHAPE~>net~>name=="rv")&&(bx1==1.025)&&(by1==3.61)
		when((cordLey2==4.25)&&((LePWidth/3)>=0.21)
		pnts=list(x1:y1 (0.975+0.09+(LePWidth/3)+0.085):y2 (0.975+0.09+(LePWidth/3)+0.085):y3 ))
		when((cordLey2==4.12)&&((LePWidth/2)>=0.21)
		pnts=list(x1:y1 (0.975+0.09+(LePWidth/2)+0.085):y2 (0.975+0.09+(LePWidth/2)+0.085):y3 ))
		when((cordLey2==3.99)&&(LePWidth>=0.21)
		pnts=list(x1:y1 (0.975+0.09+LePWidth+0.085):y2 (0.975+0.09+LePWidth+0.085):y3 ))
		when((cordLey2==4.25)&&((LePWidth/3)<0.21)
		pnts=list(x1:y1 (0.975+0.09+(LePWidth/3)+0.185):y2 (0.975+0.09+(LePWidth/3)+0.185):y3 ))
		when((cordLey2==4.12)&&((LePWidth/2)<0.21)
		pnts=list(x1:y1 (0.975+0.09+(LePWidth/2)+0.185):y2 (0.975+0.09+(LePWidth/2)+0.185):y3 ))
		when((cordLey2==3.99)&&(LePWidth<0.21)
		pnts=list(x1:y1 (0.975+0.09+LePWidth+0.185):y2 (0.975+0.09+LePWidth+0.185):y3 ))
		dbSet(SHAPE pnts "points")); moves M1 connecting the rv connecting the Poly_M1 inputs of the L.e INV gate
		when((SHAPE~>layerName=="M1")&&(bx1==0.15)&&(by1==5.01)
		when((cordR1x1>(cordnx1-0.27))
		pnts=list((cordnx1-0.43):y1 (cordnx1-0.43):y2 ))
		when((cordR1x1<=(cordnx1-0.27))
		pnts=list((cordR1x1-0.16):y1 (cordR1x1-0.16):y2 ))
		dbSet(SHAPE pnts "points")); moves M1 connecting the _r.2 connecting the Poly_M1 inputs of the INV gate
		when((SHAPE~>layerName=="M1")&&(SHAPE~>net~>name=="_r.2")&&(bx1==0.155)&&(by1==5.965)
		when((cordR1x1>(cordnx1-0.27))
		pnts=list(x1:y1 x2:y2 (cordnx1-0.43):y3 ))
		when((cordR1x1<=(cordnx1-0.27))
		pnts=list(x1:y1 x2:y2 (cordR1x1-0.16):y3 ))
		dbSet(SHAPE pnts "points")); moves M1 connecting the _r.2 connecting the M2
		when((SHAPE~>layerName=="M1")&&(SHAPE~>net~>name=="_r.0")&&(bx1==0.485)&&(by1==0.11)
		pnts=list(x1:y1 x2:y2 (cordnx1-0.16):y3 )
		dbSet(SHAPE pnts "points")); moves M1 connecting the _r.0 connecting the M2
		when((SHAPE~>layerName=="M1")&&(SHAPE~>net~>name=="_r.0")&&(bx1==0.2)&&(by1==0.945)
		when((cordR1x1>(cordnx1-0.27))
		pnts=list((cordnx1-0.43):y1 (cordnx1-0.43):y2 (cordnx1-0.16):y3 ))
		when((cordR1x1<=(cordnx1-0.27))
		pnts=list((cordR1x1-0.145):y1 (cordR1x1-0.145):y2 (cordnx1-0.16):y3 ))
		dbSet(SHAPE pnts "points")); moves M1 connecting the _r.0 connecting the poly_M1 input of the INV gate
		when((SHAPE~>layerName=="M1")&&(SHAPE~>net~>name=="_r.0")&&(bx1==0.415)&&(by1==2.635)
		bbox=list((cordrvx1+0.16):by1 (cordnx1-0.16):by2 )
		dbSet(SHAPE bbox "bBox")); moves M1 connecting the _r.0 connecting from the M2 to the Poly_M1 vias of the NAND5 gate
		when((SHAPE~>layerName=="M1")&&(SHAPE~>net~>name=="_r.2")&&(bx1==0.125)&&(by1==3.545)
		when((cordR1x1>(cordnx1-0.27))
		bbox=list((cordrvx1+0.03):by1 (cordnx1-0.43):by2 ))
		when((cordR1x1<=(cordnx1-0.27))
		bbox=list((cordrvx1+0.03):by1 (cordR1x1-0.16):by2 ))
		dbSet(SHAPE bbox "bBox")); moves M1 connecting the _r.0 connecting from the M2 to the Poly_M1 vias of the NAND5 gate
		when((SHAPE~>layerName=="M1")&&(SHAPE~>net~>name=="_RESET")&&(bx1==1.48)&&(by1==2.115)
		when((cordR2x2<(cordpx1+0.27))
		bbox=list((cordResx2-0.07):by1 (cordpx1+0.04):by2 ))
		when((cordR2x2>=(cordpx1+0.27))
		bbox=list((cordResx2-0.07):by1 (cordR2x2-0.235):by2 ))
		dbSet(SHAPE bbox "bBox")); moves M1 connecting the _RESET connecting from the M2 to the Poly_M1 vias of the INV gate
		when((SHAPE~>layerName=="M1")&&(SHAPE~>net~>name=="Reset")&&(bx1==0.55)&&(by1==2.05)
		pnts=list(x1:y1 (cordresx1+0.07):y2 (cordresx1+0.07):y3 )
		dbSet(SHAPE pnts "points")); moves M1 connecting the _RESET connecting from the M2 to the Poly_M1 vias of the INV gate
		when((SHAPE~>layerName=="M1")&&(SHAPE~>net~>name=="_Reset")&&(bx1==0.975)&&(by1==2.31)
		pnts=list(x1:y1 (cordrvx3-0.33):y2 (cordrvx3-0.33):y3 )
		dbSet(SHAPE pnts "points")); moves M1 connecting the _Reset connecting from the M2 to the Poly_M1 vias of the NAND5 gate
		when((SHAPE~>layerName=="M1")&&(SHAPE~>net~>name=="_r.1")&&(by1==2.765)&&(bx1==1.48)
		when((cordR2x2<(cordpx1+0.27))&&((cordR2x2+0.285)>=(cordrvx3-0.24))
		bbox=list((cordrvx3-0.2):by1 (cordpx1+0.56):by2))
		when((cordR2x2<(cordpx1+0.27))&&((cordR2x2+0.285)<(cordrvx3-0.24))
		bbox=list((cordrvx3-0.2):(by1+0.65) (cordpx1+0.56):(by2+0.65)))
		when((cordR2x2>=(cordpx1+0.27))&&((cordR2x2+0.285)>=(cordrvx3-0.24))
		bbox=list((cordrvx3-0.2):by1 (cordR2x2+0.285):by2))
		when((cordR2x2>=(cordpx1+0.27))&&((cordR2x2+0.285)<(cordrvx3-0.24))
		bbox=list((cordrvx3-0.2):(by1+0.65) (cordR2x2+0.285):(by2+0.65)))
		dbSet(SHAPE bbox "bBox")); moves M1 connecting the M2_M1 via of _r.1 connecting to the Poly_M1 via of NAND5 gate
		when((SHAPE~>layerName=="M3")&&((SHAPE~>net~>name=="L.3")||(SHAPE~>net~>name=="L.2")||(SHAPE~>net~>name=="L.1")||(SHAPE~>net~>name=="L.0")||(SHAPE~>net~>name=="L.e"))
	when((ActualLeftPoly<=cordrvx4)&&(ActualLeftPoly<=cordLex4)
		when(((cordrvx4<=cordLex4)&&(cordrvx4<=(cordnx1-0.5)))&&(cordR1x1>(cordnx1-0.27))
		bbox=list(cordrvx4:by1 bx2:by2))
		when(((cordrvx4<=cordLex4)&&(cordrvx4<=(cordnx1-0.5)))&&(cordR1x1<=(cordnx1-0.27))
		bbox=list(cordR1x1-0.23:by1 bx2:by2))
		when(((cordLex4<cordrvx4)&&(cordLex4<=(cordnx1-0.5)))&&(cordR1x1>(cordnx1-0.27))
		bbox=list(cordLex4:by1 bx2:by2))
		when(((cordLex4<cordrvx4)&&(cordLex4<=(cordnx1-0.5)))&&(cordR1x1<=(cordnx1-0.27))
		bbox=list(cordR1x1-0.23:by1 bx2:by2))
		when((((cordnx1-0.5)<cordLex4)&&((cordnx1-0.5)<=cordrvx4))&&(cordR1x1>(cordnx1-0.27))
		bbox=list((cordnx1-0.5):by1 bx2:by2))
		when((((cordnx1-0.5)<cordLex4)&&((cordnx1-0.5)<=cordrvx4))&&(cordR1x1<=(cordnx1-0.27))
		bbox=list((cordR1x1-0.23):by1 bx2:by2)))
	when((ActualLeftPoly>cordrvx4)||(ActualLeftPoly>cordLex4)
		when((cordrvx4<=cordLex4)
		bbox=list((cordrvx4-0.04):by1 bx2:by2))
		when((cordLex4<cordrvx4)
		bbox=list((cordLex4-0.04):by1 bx2:by2)))
		dbSet(SHAPE bbox "bBox")) ;moves M3 pins L.3/L.2/L.1/L.0
		when((SHAPE~>layerName=="M3")&&((SHAPE~>net~>name=="R.3")||(SHAPE~>net~>name=="R.2")||(SHAPE~>net~>name=="R.1")||(SHAPE~>net~>name=="R.0")||(SHAPE~>net~>name=="R.e"))
		when(((cordrvx3>=cordLex3)&&(cordrvx3>=cordR1x3))
		bbox=list(bx1:by1 cordrvx3:by2))
		when(((cordLex3>cordrvx3)&&(cordLex3>=cordR1x3))
		bbox=list(bx1:by1 cordLex3:by2))
		when(((cordR1x3>cordrvx3)&&(cordR1x3>cordLex3))
		bbox=list(bx1:by1 cordR1x3:by2))
		dbSet(SHAPE bbox "bBox")) ;moves M3 pins R.3/R.2/R.1/R.0
		when((SHAPE~>layerName=="M3")&&(SHAPE~>net~>name=="_RESET")
		when(((cordrvx3>=cordLex3)&&(cordrvx3>=cordR1x3))&&((cordrvx4<=cordLex4)&&(cordrvx4<=(cordnx1-0.5)))
		bbox=list(cordrvx4:by1 cordrvx3:by2))
		when(((cordrvx3>=cordLex3)&&(cordrvx3>=cordR1x3))&&((cordLex4<cordrvx4)&&(cordLex4<=(cordnx1-0.5)))
		bbox=list(cordLex4:by1 cordrvx3:by2))
		when(((cordrvx3>=cordLex3)&&(cordrvx3>=cordR1x3))&&(((cordnx1-0.5)<cordLex4)&&((cordnx1-0.5)<=cordrvx4))
		bbox=list((cordnx1-0.5):by1 cordrvx3:by2))
		when(((cordLex3>cordrvx3)&&(cordLex3>=cordR1x3))&&((cordrvx4<=cordLex4)&&(cordrvx4<=(cordnx1-0.5)))
		bbox=list(cordrvx4:by1 cordLex3:by2))
		when(((cordLex3>cordrvx3)&&(cordLex3>=cordR1x3))&&((cordLex4<cordrvx4)&&(cordLex4<=(cordnx1-0.5)))
		bbox=list(cordLex4:by1 cordLex3:by2))
		when(((cordLex3>cordrvx3)&&(cordLex3>=cordR1x3))&&(((cordnx1-0.5)<cordLex4)&&((cordnx1-0.5)<=cordrvx4))
		bbox=list((cordnx1-0.5):by1 cordLex3:by2))
		when(((cordR1x3>cordrvx3)&&(cordR1x3>cordLex3))&&((cordrvx4<=cordLex4)&&(cordrvx4<=(cordnx1-0.5)))
		bbox=list(cordrvx4:by1 cordR1x3:by2))
		when(((cordR1x3>cordrvx3)&&(cordR1x3>cordLex3))&&((cordLex4<cordrvx4)&&(cordLex4<=(cordnx1-0.5)))
		bbox=list(cordLex4:by1 cordR1x3:by2))
		when(((cordR1x3>cordrvx3)&&(cordR1x3>cordLex3))&&(((cordnx1-0.5)<cordLex4)&&((cordnx1-0.5)<=cordrvx4))
		bbox=list((cordnx1-0.5):by1 cordR1x3:by2))
		dbSet(SHAPE bbox "bBox")) ; stretches M3 _RESET pin
		when((SHAPE~>layerName=="M1")&&(SHAPE~>net~>name=="_r.3")&&(bx1==1.645)&&(by1==3.675)
		when(((cordpx1+0.5)>cordLex3)&&(cordR2x2<(cordpx1+0.27))
		pnts=list((cordrvx3-0.07):y1 (cordpx1+0.56):y2 (cordpx1+0.56):y3 (cordpx1+0.53):y4))
		when(((cordpx1+0.5)>cordLex3)&&(cordR2x2>=(cordpx1+0.27))
		pnts=list((cordrvx3-0.07):y1 (cordR2x2+0.285):y2 (cordR2x2+0.285):y3 (cordR2x2+0.255):y4))
		when(((cordpx1+0.5)<cordLex3)&&(cordR2x2<(cordpx1+0.27))
		pnts=list((cordrvx3-0.07):y1 (cordrvx3-0.07):y2 (cordrvx3-0.07):y3 (cordpx1+0.53):y4))
		when(((cordpx1+0.5)<cordLex3)&&(cordR2x2>=(cordpx1+0.27))
		pnts=list((cordrvx3-0.07):y1 (cordrvx3-0.07):y2 (cordrvx3-0.07):y3 (cordR2x2+0.255):y4))
		dbSet(SHAPE pnts "points")); moves M1 connecting the _Reset connecting from the M2 to the Poly_M1 vias of the NAND5 gate
		when((SHAPE~>layerName=="prBoundary")
		dbDeleteObject(SHAPE)
	when((ActualLeftPoly<=cordrvx4)&&(ActualLeftPoly<=cordLex4)
		when(((cordrvx3>=cordLex3)&&(cordrvx3>=cordR1x3))&&((cordrvx4<=cordLex4)&&(cordrvx4<=(cordnx1-0.5)))&&(cordR1x1>(cordnx1-0.27))&&(cordR2x2<(cordpx1+0.27))
		pnts=list((cordrvx4-0.04):by1 (cordrvx4-0.04):by2 (cordrvx3+0.04):by2 (cordrvx3+0.04):by1))
		when(((cordrvx3>=cordLex3)&&(cordrvx3>=cordR1x3))&&((cordrvx4<=cordLex4)&&(cordrvx4<=(cordnx1-0.5)))&&(cordR1x1<=(cordnx1-0.27))&&(cordR2x2>=(cordpx1+0.27))
		pnts=list((cordR1x1-0.27):by1 (cordR1x1-0.27):by2 (cordrvx3+0.04):by2 (cordrvx3+0.04):by1))
		when(((cordrvx3>=cordLex3)&&(cordrvx3>=cordR1x3))&&((cordrvx4<=cordLex4)&&(cordrvx4<=(cordnx1-0.5)))&&(cordR1x1<=(cordnx1-0.27))&&(cordR2x2<(cordpx1+0.27))
		pnts=list((cordR1x1-0.27):by1 (cordR1x1-0.27):by2 (cordrvx3+0.04):by2 (cordrvx3+0.04):by1))
		when(((cordrvx3>=cordLex3)&&(cordrvx3>=cordR1x3))&&((cordrvx4<=cordLex4)&&(cordrvx4<=(cordnx1-0.5)))&&(cordR1x1>(cordnx1-0.27))&&(cordR2x2>=(cordpx1+0.27))
		pnts=list((cordrvx4-0.04):by1 (cordrvx4-0.04):by2 (cordrvx3+0.04):by2 (cordrvx3+0.04):by1))
		when(((cordrvx3>=cordLex3)&&(cordrvx3>=cordR1x3))&&((cordLex4<cordrvx4)&&(cordLex4<=(cordnx1-0.5)))&&(cordR1x1>(cordnx1-0.27))&&(cordR2x2<(cordpx1+0.27))
		pnts=list((cordLex4-0.04):by1 (cordLex4-0.04):by2 (cordrvx3+0.04):by2 (cordrvx3+0.04):by1))
		when(((cordrvx3>=cordLex3)&&(cordrvx3>=cordR1x3))&&((cordLex4<cordrvx4)&&(cordLex4<=(cordnx1-0.5)))&&(cordR1x1<=(cordnx1-0.27))&&(cordR2x2>=(cordpx1+0.27))
		pnts=list((cordR1x1-0.27):by1 (cordR1x1-0.27):by2 (cordrvx3+0.04):by2 (cordrvx3+0.04):by1))
		when(((cordrvx3>=cordLex3)&&(cordrvx3>=cordR1x3))&&((cordLex4<cordrvx4)&&(cordLex4<=(cordnx1-0.5)))&&(cordR1x1<=(cordnx1-0.27))&&(cordR2x2<(cordpx1+0.27))
		pnts=list((cordR1x1-0.27):by1 (cordR1x1-0.27):by2 (cordrvx3+0.04):by2 (cordrvx3+0.04):by1))
		when(((cordrvx3>=cordLex3)&&(cordrvx3>=cordR1x3))&&((cordLex4<cordrvx4)&&(cordLex4<=(cordnx1-0.5)))&&(cordR1x1>(cordnx1-0.27))&&(cordR2x2>=(cordpx1+0.27))
		pnts=list((cordLex4-0.04):by1 (cordLex4-0.04):by2 (cordrvx3+0.04):by2 (cordrvx3+0.04):by1))
		when(((cordrvx3>=cordLex3)&&(cordrvx3>=cordR1x3))&&(((cordnx1-0.5)<cordLex4)&&((cordnx1-0.5)<=cordrvx4))&&(cordR1x1>(cordnx1-0.27))&&(cordR2x2<(cordpx1+0.27))
		pnts=list((cordnx1-0.54):by1 (cordnx1-0.54):by2 (cordrvx3+0.04):by2 (cordrvx3+0.04):by1))
		when(((cordrvx3>=cordLex3)&&(cordrvx3>=cordR1x3))&&(((cordnx1-0.5)<cordLex4)&&((cordnx1-0.5)<=cordrvx4))&&(cordR1x1<=(cordnx1-0.27))&&(cordR2x2>=(cordpx1+0.27))
		pnts=list((cordR1x1-0.27):by1 (cordR1x1-0.27):by2 (cordrvx3+0.04):by2 (cordrvx3+0.04):by1))
		when(((cordrvx3>=cordLex3)&&(cordrvx3>=cordR1x3))&&(((cordnx1-0.5)<cordLex4)&&((cordnx1-0.5)<=cordrvx4))&&(cordR1x1<=(cordnx1-0.27))&&(cordR2x2<(cordpx1+0.27))
		pnts=list((cordR1x1-0.27):by1 (cordR1x1-0.27):by2 (cordrvx3+0.04):by2 (cordrvx3+0.04):by1))
		when(((cordrvx3>=cordLex3)&&(cordrvx3>=cordR1x3))&&(((cordnx1-0.5)<cordLex4)&&((cordnx1-0.5)<=cordrvx4))&&(cordR1x1>(cordnx1-0.27))&&(cordR2x2>=(cordpx1+0.27))
		pnts=list((cordnx1-0.54):by1 (cordnx1-0.54):by2 (cordrvx3+0.04):by2 (cordrvx3+0.04):by1))
		when(((cordLex3>cordrvx3)&&(cordLex3>=cordR1x3))&&((cordrvx4<=cordLex4)&&(cordrvx4<=(cordnx1-0.5)))&&(cordR1x1>(cordnx1-0.27))&&(cordR2x2<(cordpx1+0.27))
		pnts=list((cordrvx4-0.04):by1 (cordrvx4-0.04):by2 (cordLex3+0.04):by2 (cordLex3+0.04):by1))
		when(((cordLex3>cordrvx3)&&(cordLex3>=cordR1x3))&&((cordrvx4<=cordLex4)&&(cordrvx4<=(cordnx1-0.5)))&&(cordR1x1<=(cordnx1-0.27))&&(cordR2x2>=(cordpx1+0.27))
		pnts=list((cordR1x1-0.27):by1 (cordR1x1-0.27):by2 (cordLex3+0.04):by2 (cordLex3+0.04):by1))
		when(((cordLex3>cordrvx3)&&(cordLex3>=cordR1x3))&&((cordrvx4<=cordLex4)&&(cordrvx4<=(cordnx1-0.5)))&&(cordR1x1<=(cordnx1-0.27))&&(cordR2x2<(cordpx1+0.27))
		pnts=list((cordR1x1-0.27):by1 (cordR1x1-0.27):by2 (cordLex3+0.04):by2 (cordLex3+0.04):by1))
		when(((cordLex3>cordrvx3)&&(cordLex3>=cordR1x3))&&((cordrvx4<=cordLex4)&&(cordrvx4<=(cordnx1-0.5)))&&(cordR1x1>(cordnx1-0.27))&&(cordR2x2>=(cordpx1+0.27))
		pnts=list((cordrvx4-0.04):by1 (cordrvx4-0.04):by2 (cordLex3+0.04):by2 (cordLex3+0.04):by1))
		when(((cordLex3>cordrvx3)&&(cordLex3>=cordR1x3))&&((cordLex4<cordrvx4)&&(cordLex4<=(cordnx1-0.5)))&&(cordR1x1>(cordnx1-0.27))&&(cordR2x2<(cordpx1+0.27))
		pnts=list((cordLex4-0.04):by1 (cordLex4-0.04):by2 (cordLex3+0.04):by2 (cordLex3+0.04):by1))
		when(((cordLex3>cordrvx3)&&(cordLex3>=cordR1x3))&&((cordLex4<cordrvx4)&&(cordLex4<=(cordnx1-0.5)))&&(cordR1x1<=(cordnx1-0.27))&&(cordR2x2>=(cordpx1+0.27))
		pnts=list((cordR1x1-0.04):by1 (cordR1x1-0.04):by2 (cordLex3+0.04):by2 (cordLex3+0.04):by1))
		when(((cordLex3>cordrvx3)&&(cordLex3>=cordR1x3))&&((cordLex4<cordrvx4)&&(cordLex4<=(cordnx1-0.5)))&&(cordR1x1<=(cordnx1-0.27))&&(cordR2x2<(cordpx1+0.27))
		pnts=list((cordR1x1-0.27):by1 (cordR1x1-0.27):by2 (cordLex3+0.04):by2 (cordLex3+0.04):by1))
		when(((cordLex3>cordrvx3)&&(cordLex3>=cordR1x3))&&((cordLex4<cordrvx4)&&(cordLex4<=(cordnx1-0.5)))&&(cordR1x1>(cordnx1-0.27))&&(cordR2x2>=(cordpx1+0.27))
		pnts=list((cordLex4-0.04):by1 (cordLex4-0.04):by2 (cordLex3+0.04):by2 (cordLex3+0.04):by1))
		when(((cordLex3>cordrvx3)&&(cordLex3>=cordR1x3))&&(((cordnx1-0.5)<cordLex4)&&((cordnx1-0.5)<=cordrvx4))&&(cordR1x1>(cordnx1-0.27))&&(cordR2x2<(cordpx1+0.27))
		pnts=list((cordnx1-0.54):by1 (cordnx1-0.54):by2 (cordLex3+0.04):by2 (cordLex3+0.04):by1))
		when(((cordLex3>cordrvx3)&&(cordLex3>=cordR1x3))&&(((cordnx1-0.5)<cordLex4)&&((cordnx1-0.5)<=cordrvx4))&&(cordR1x1<=(cordnx1-0.27))&&(cordR2x2>=(cordpx1+0.27))
		pnts=list((cordR1x1-0.27):by1 (cordR1x1-0.27):by2 (cordLex3+0.04):by2 (cordLex3+0.04):by1))
		when(((cordLex3>cordrvx3)&&(cordLex3>=cordR1x3))&&(((cordnx1-0.5)<cordLex4)&&((cordnx1-0.5)<=cordrvx4))&&(cordR1x1<=(cordnx1-0.27))&&(cordR2x2<(cordpx1+0.27))
		pnts=list((cordR1x1-0.27):by1 (cordR1x1-0.27):by2 (cordLex3+0.04):by2 (cordLex3+0.04):by1))
		when(((cordLex3>cordrvx3)&&(cordLex3>=cordR1x3))&&(((cordnx1-0.5)<cordLex4)&&((cordnx1-0.5)<=cordrvx4))&&(cordR1x1>(cordnx1-0.27))&&(cordR2x2>=(cordpx1+0.27))
		pnts=list((cordnx1-0.54):by1 (cordnx1-0.54):by2 (cordLex3+0.04):by2 (cordLex3+0.04):by1))
		when(((cordR1x3>cordrvx3)&&(cordR1x3>cordLex3))&&((cordrvx4<=cordLex4)&&(cordrvx4<=(cordnx1-0.5)))&&(cordR1x1>(cordnx1-0.27))&&(cordR2x2<(cordpx1+0.27))
		pnts=list((cordrvx4-0.04):by1 (cordrvx4-0.04):by2 (cordR1x3+0.04):by2 (cordR1x3+0.04):by1))
		when(((cordR1x3>cordrvx3)&&(cordR1x3>cordLex3))&&((cordrvx4<=cordLex4)&&(cordrvx4<=(cordnx1-0.5)))&&(cordR1x1<=(cordnx1-0.27))&&(cordR2x2>=(cordpx1+0.27))
		pnts=list((cordR1x1-0.27):by1 (cordR1x1-0.27):by2 (cordR1x3+0.04):by2 (cordR1x3+0.04):by1))
		when(((cordR1x3>cordrvx3)&&(cordR1x3>cordLex3))&&((cordrvx4<=cordLex4)&&(cordrvx4<=(cordnx1-0.5)))&&(cordR1x1<=(cordnx1-0.27))&&(cordR2x2<(cordpx1+0.27))
		pnts=list((cordR1x1-0.27):by1 (cordR1x1-0.27):by2 (cordR1x3+0.04):by2 (cordR1x3+0.04):by1))
		when(((cordR1x3>cordrvx3)&&(cordR1x3>cordLex3))&&((cordrvx4<=cordLex4)&&(cordrvx4<=(cordnx1-0.5)))&&(cordR1x1>(cordnx1-0.27))&&(cordR2x2>=(cordpx1+0.27))
		pnts=list((cordrvx4-0.04):by1 (cordrvx4-0.04):by2 (cordR1x2+0.04):by2 (cordR1x2+0.04):by1))
		when(((cordR1x3>cordrvx3)&&(cordR1x3>cordLex3))&&((cordLex4<cordrvx4)&&(cordLex4<=(cordnx1-0.5)))&&(cordR1x1>(cordnx1-0.27))&&(cordR2x2<(cordpx1+0.27))
		pnts=list((cordLex4-0.04):by1 (cordLex4-0.04):by2 (cordR1x3+0.04):by2 (cordR1x3+0.04):by1))
		when(((cordR1x3>cordrvx3)&&(cordR1x3>cordLex3))&&((cordLex4<cordrvx4)&&(cordLex4<=(cordnx1-0.5)))&&(cordR1x1<=(cordnx1-0.27))&&(cordR2x2>=(cordpx1+0.27))
		pnts=list((cordR1x1-0.27):by1 (cordR1x1-0.27):by2 (cordR1x3+0.04):by2 (cordR1x3+0.04):by1))
		when(((cordR1x3>cordrvx3)&&(cordR1x3>cordLex3))&&((cordLex4<cordrvx4)&&(cordLex4<=(cordnx1-0.5)))&&(cordR1x1<=(cordnx1-0.27))&&(cordR2x2<(cordpx1+0.27))
		pnts=list((cordR1x1-0.27):by1 (cordR1x1-0.27):by2 (cordR1x3+0.04):by2 (cordR1x3+0.04):by1))
		when(((cordR1x3>cordrvx3)&&(cordR1x3>cordLex3))&&((cordLex4<cordrvx4)&&(cordLex4<=(cordnx1-0.5)))&&(cordR1x1>(cordnx1-0.27))&&(cordR2x2>=(cordpx1+0.27))
		pnts=list((cordLex4-0.04):by1 (cordLex4-0.04):by2 (cordR1x3+0.04):by2 (cordR1x3+0.04):by1))
		when(((cordR1x3>cordrvx3)&&(cordR1x3>cordLex3))&&(((cordnx1-0.5)<cordLex4)&&((cordnx1-0.5)<=cordrvx4))&&(cordR1x1>(cordnx1-0.27))&&(cordR2x2<(cordpx1+0.27))
		pnts=list((cordnx1-0.54):by1 (cordnx1-0.54):by2 (cordR1x3+0.04):by2 (cordR1x3+0.04):by1))
		when(((cordR1x3>cordrvx3)&&(cordR1x3>cordLex3))&&(((cordnx1-0.5)<cordLex4)&&((cordnx1-0.5)<=cordrvx4))&&(cordR1x1<=(cordnx1-0.27))&&(cordR2x2>=(cordpx1+0.27))
		pnts=list((cordR1x1-0.27):by1 (cordR1x1-0.27):by2 (cordR1x3+0.04):by2  (cordR1x3+0.04):by1))
		when(((cordR1x3>cordrvx3)&&(cordR1x3>cordLex3))&&(((cordnx1-0.5)<cordLex4)&&((cordnx1-0.5)<=cordrvx4))&&(cordR1x1<=(cordnx1-0.27))&&(cordR2x2<(cordpx1+0.27))
		pnts=list((cordR1x1-0.27):by1 (cordR1x1-0.27):by2 (cordR1x3+0.04):by2 (cordR1x3+0.04):by1))
		when(((cordR1x3>cordrvx3)&&(cordR1x3>cordLex3))&&(((cordnx1-0.5)<cordLex4)&&((cordnx1-0.5)<=cordrvx4))&&(cordR1x1>(cordnx1-0.27))&&(cordR2x2>=(cordpx1+0.27))
		pnts=list((cordnx1-0.54):by1 (cordnx1-0.54):by2 (cordR1x3+0.04):by2 (cordR1x3+0.04):by1)))
	when((ActualLeftPoly>cordrvx4)||(ActualLeftPoly>cordLex4)
		when((cordrvx4<=cordLex4)&&(cordrvx3>=cordLex3)&&(cordrvx3>=cordR1x3)
		pnts=list((cordrvx4-0.04):by1 (cordrvx4-0.04):by2 (cordrvx3+0.04):by2 (cordrvx3+0.04):by1))
		when((cordrvx4<=cordLex4)&&(cordLex3>cordrvx3)&&(cordLex3>=cordR1x3)
		pnts=list((cordrvx4-0.04):by1 (cordrvx4-0.04):by2 (cordLex3+0.04):by2 (cordLex3+0.04):by1))
		when((cordrvx4<=cordLex4)&&(cordR1x3>cordrvx3)&&(cordR1x3>cordLex3)
		pnts=list((cordrvx4-0.04):by1 (cordrvx4-0.04):by2 (cordR1x3+0.04):by2 (cordR1x3+0.04):by1))
		when((cordLex4<cordrvx4)&&(cordrvx3>=cordLex3)&&(cordrvx3>=cordR1x3)
		pnts=list((cordLex4-0.04):by1 (cordLex4-0.04):by2 (cordR1x3+0.04):by2 (cordR1x3+0.04):by1))
		when((cordLex4<cordrvx4)&&(cordLex3>cordrvx3)&&(cordLex3>=cordR1x3)
		pnts=list((cordLex4-0.04):by1 (cordLex4-0.04):by2 (cordR1x3+0.04):by2  (cordR1x3+0.04):by1))
		when((cordLex4<cordrvx4)&&(cordR1x3>cordrvx3)&&(cordR1x3>cordLex3)
		pnts=list((cordLex4-0.04):by1 (cordLex4-0.04):by2 (cordR1x3+0.04):by2  (cordR1x3+0.04):by1)))
		dbCreatePRBoundary(CellView pnts)); moves prBoundary
		when((SHAPE~>layerName=="M3")&&((bx1==0&&by2==0.095&&bx2==2.08)||(bx1==0&&by2==1.535&&bx2==2.08)||(bx1==0&&by2==1.655&&bx2==2.08)||(bx1==0&&by2==3.095&&bx2==2.08)||(bx1==0&&by2==3.215&&bx2==2.08)||(bx1==0&&by2==4.655&&bx2==2.08)||(bx1==0&&by2==4.775&&bx2==2.08)||(bx1==0&&by2==6.215&&bx2==2.08))
	when((ActualLeftPoly<=cordrvx4)&&(ActualLeftPoly<=cordLex4)
		when(((cordrvx3>=cordLex3)&&(cordrvx3>=cordR1x3))&&((cordrvx4<=cordLex4)&&(cordrvx4<=(cordnx1-0.5)))&&(cordR1x1>(cordnx1-0.27))&&(cordR2x2<(cordpx1+0.27))
		bbox=list((cordrvx4-0.04):by1 (cordrvx3+0.04):by2))
		when(((cordrvx3>=cordLex3)&&(cordrvx3>=cordR1x3))&&((cordrvx4<=cordLex4)&&(cordrvx4<=(cordnx1-0.5)))&&(cordR1x1<=(cordnx1-0.27))&&(cordR2x2>=(cordpx1+0.27))
		bbox=list((cordR1x1-0.27):by1 (cordrvx3+0.04):by2))
		when(((cordrvx3>=cordLex3)&&(cordrvx3>=cordR1x3))&&((cordrvx4<=cordLex4)&&(cordrvx4<=(cordnx1-0.5)))&&(cordR1x1<=(cordnx1-0.27))&&(cordR2x2<(cordpx1+0.27))
		bbox=list((cordR1x1-0.27):by1 (cordrvx3+0.04):by2))
		when(((cordrvx3>=cordLex3)&&(cordrvx3>=cordR1x3))&&((cordrvx4<=cordLex4)&&(cordrvx4<=(cordnx1-0.5)))&&(cordR1x1>(cordnx1-0.27))&&(cordR2x2>=(cordpx1+0.27))
		bbox=list((cordrvx4-0.04):by1 (cordrvx3+0.04):by2))
		when(((cordrvx3>=cordLex3)&&(cordrvx3>=cordR1x3))&&((cordLex4<cordrvx4)&&(cordLex4<=(cordnx1-0.5)))&&(cordR1x1>(cordnx1-0.27))&&(cordR2x2<(cordpx1+0.27))
		bbox=list((cordLex4-0.04):by1 (cordrvx3+0.04):by2))
		when(((cordrvx3>=cordLex3)&&(cordrvx3>=cordR1x3))&&((cordLex4<cordrvx4)&&(cordLex4<=(cordnx1-0.5)))&&(cordR1x1<=(cordnx1-0.27))&&(cordR2x2>=(cordpx1+0.27))
		bbox=list((cordR1x1-0.27):by1 (cordrvx3+0.04):by2))
		when(((cordrvx3>=cordLex3)&&(cordrvx3>=cordR1x3))&&((cordLex4<cordrvx4)&&(cordLex4<=(cordnx1-0.5)))&&(cordR1x1<=(cordnx1-0.27))&&(cordR2x2<(cordpx1+0.27))
		bbox=list((cordR1x1-0.27):by1 (cordrvx3+0.04):by2))
		when(((cordrvx3>=cordLex3)&&(cordrvx3>=cordR1x3))&&((cordLex4<cordrvx4)&&(cordLex4<=(cordnx1-0.5)))&&(cordR1x1>(cordnx1-0.27))&&(cordR2x2>=(cordpx1+0.27))
		bbox=list((cordLex4-0.04):by1 (cordrvx3+0.04):by2))
		when(((cordrvx3>=cordLex3)&&(cordrvx3>=cordR1x3))&&(((cordnx1-0.5)<cordLex4)&&((cordnx1-0.5)<=cordrvx4))&&(cordR1x1>(cordnx1-0.27))&&(cordR2x2<(cordpx1+0.27))
		bbox=list((cordnx1-0.54):by1 (cordrvx3+0.04):by2))
		when(((cordrvx3>=cordLex3)&&(cordrvx3>=cordR1x3))&&(((cordnx1-0.5)<cordLex4)&&((cordnx1-0.5)<=cordrvx4))&&(cordR1x1<=(cordnx1-0.27))&&(cordR2x2>=(cordpx1+0.27))
		bbox=list((cordR1x1-0.27):by1 (cordrvx3+0.04):by2))
		when(((cordrvx3>=cordLex3)&&(cordrvx3>=cordR1x3))&&(((cordnx1-0.5)<cordLex4)&&((cordnx1-0.5)<=cordrvx4))&&(cordR1x1<=(cordnx1-0.27))&&(cordR2x2<(cordpx1+0.27))
		bbox=list((cordR1x1-0.27):by1 (cordrvx3+0.04):by2))
		when(((cordrvx3>=cordLex3)&&(cordrvx3>=cordR1x3))&&(((cordnx1-0.5)<cordLex4)&&((cordnx1-0.5)<=cordrvx4))&&(cordR1x1>(cordnx1-0.27))&&(cordR2x2>=(cordpx1+0.27))
		bbox=list((cordnx1-0.54):by1 (cordrvx3+0.04):by2))
		when(((cordLex3>cordrvx3)&&(cordLex3>=cordR1x3))&&((cordrvx4<=cordLex4)&&(cordrvx4<=(cordnx1-0.5)))&&(cordR1x1>(cordnx1-0.27))&&(cordR2x2<(cordpx1+0.27))
		bbox=list((cordrvx4-0.04):by1 (cordLex3+0.04):by2))
		when(((cordLex3>cordrvx3)&&(cordLex3>=cordR1x3))&&((cordrvx4<=cordLex4)&&(cordrvx4<=(cordnx1-0.5)))&&(cordR1x1<=(cordnx1-0.27))&&(cordR2x2>=(cordpx1+0.27))
		bbox=list((cordR1x1-0.27):by1 (cordLex3+0.04):by2))
		when(((cordLex3>cordrvx3)&&(cordLex3>=cordR1x3))&&((cordrvx4<=cordLex4)&&(cordrvx4<=(cordnx1-0.5)))&&(cordR1x1<=(cordnx1-0.27))&&(cordR2x2<(cordpx1+0.27))
		bbox=list((cordR1x1-0.27):by1 (cordLex3+0.04):by2))
		when(((cordLex3>cordrvx3)&&(cordLex3>=cordR1x3))&&((cordrvx4<=cordLex4)&&(cordrvx4<=(cordnx1-0.5)))&&(cordR1x1>(cordnx1-0.27))&&(cordR2x2>=(cordpx1+0.27))
		bbox=list((cordrvx4-0.04):by1 (cordLex3+0.04):by2))
		when(((cordLex3>cordrvx3)&&(cordLex3>=cordR1x3))&&((cordLex4<cordrvx4)&&(cordLex4<=(cordnx1-0.5)))&&(cordR1x1>(cordnx1-0.27))&&(cordR2x2<(cordpx1+0.27))
		bbox=list((cordLex4-0.04):by1 (cordLex3+0.04):by2))
		when(((cordLex3>cordrvx3)&&(cordLex3>=cordR1x3))&&((cordLex4<cordrvx4)&&(cordLex4<=(cordnx1-0.5)))&&(cordR1x1<=(cordnx1-0.27))&&(cordR2x2>=(cordpx1+0.27))
		bbox=list((cordR1x1-0.04):by1 (cordLex3+0.04):by2))
		when(((cordLex3>cordrvx3)&&(cordLex3>=cordR1x3))&&((cordLex4<cordrvx4)&&(cordLex4<=(cordnx1-0.5)))&&(cordR1x1<=(cordnx1-0.27))&&(cordR2x2<(cordpx1+0.27))
		bbox=list((cordR1x1-0.27):by1 (cordLex3+0.04):by2))
		when(((cordLex3>cordrvx3)&&(cordLex3>=cordR1x3))&&((cordLex4<cordrvx4)&&(cordLex4<=(cordnx1-0.5)))&&(cordR1x1>(cordnx1-0.27))&&(cordR2x2>=(cordpx1+0.27))
		bbox=list((cordLex4-0.04):by1 (cordLex3+0.04):by2))
		when(((cordLex3>cordrvx3)&&(cordLex3>=cordR1x3))&&(((cordnx1-0.5)<cordLex4)&&((cordnx1-0.5)<=cordrvx4))&&(cordR1x1>(cordnx1-0.27))&&(cordR2x2<(cordpx1+0.27))
		bbox=list((cordnx1-0.54):by1 (cordLex3+0.04):by2))
		when(((cordLex3>cordrvx3)&&(cordLex3>=cordR1x3))&&(((cordnx1-0.5)<cordLex4)&&((cordnx1-0.5)<=cordrvx4))&&(cordR1x1<=(cordnx1-0.27))&&(cordR2x2>=(cordpx1+0.27))
		bbox=list((cordR1x1-0.27):by1 (cordLex3+0.04):by2))
		when(((cordLex3>cordrvx3)&&(cordLex3>=cordR1x3))&&(((cordnx1-0.5)<cordLex4)&&((cordnx1-0.5)<=cordrvx4))&&(cordR1x1<=(cordnx1-0.27))&&(cordR2x2<(cordpx1+0.27))
		bbox=list((cordR1x1-0.27):by1 (cordLex3+0.04):by2))
		when(((cordLex3>cordrvx3)&&(cordLex3>=cordR1x3))&&(((cordnx1-0.5)<cordLex4)&&((cordnx1-0.5)<=cordrvx4))&&(cordR1x1>(cordnx1-0.27))&&(cordR2x2>=(cordpx1+0.27))
		bbox=list((cordnx1-0.54):by1 (cordLex3+0.04):by2))
		when(((cordR1x3>cordrvx3)&&(cordR1x3>cordLex3))&&((cordrvx4<=cordLex4)&&(cordrvx4<=(cordnx1-0.5)))&&(cordR1x1>(cordnx1-0.27))&&(cordR2x2<(cordpx1+0.27))
		bbox=list((cordrvx4-0.04):by1 (cordR1x3+0.04):by2))
		when(((cordR1x3>cordrvx3)&&(cordR1x3>cordLex3))&&((cordrvx4<=cordLex4)&&(cordrvx4<=(cordnx1-0.5)))&&(cordR1x1<=(cordnx1-0.27))&&(cordR2x2>=(cordpx1+0.27))
		bbox=list((cordR1x1-0.27):by1 (cordR1x3+0.04):by2))
		when(((cordR1x3>cordrvx3)&&(cordR1x3>cordLex3))&&((cordrvx4<=cordLex4)&&(cordrvx4<=(cordnx1-0.5)))&&(cordR1x1<=(cordnx1-0.27))&&(cordR2x2<(cordpx1+0.27))
		bbox=list((cordR1x1-0.27):by1 (cordR1x3+0.04):by2))
		when(((cordR1x3>cordrvx3)&&(cordR1x3>cordLex3))&&((cordrvx4<=cordLex4)&&(cordrvx4<=(cordnx1-0.5)))&&(cordR1x1>(cordnx1-0.27))&&(cordR2x2>=(cordpx1+0.27))
		bbox=list((cordrvx4-0.04):by1 (cordR1x2+0.04):by2))
		when(((cordR1x3>cordrvx3)&&(cordR1x3>cordLex3))&&((cordLex4<cordrvx4)&&(cordLex4<=(cordnx1-0.5)))&&(cordR1x1>(cordnx1-0.27))&&(cordR2x2<(cordpx1+0.27))
		bbox=list((cordLex4-0.04):by1 (cordR1x3+0.04):by2))
		when(((cordR1x3>cordrvx3)&&(cordR1x3>cordLex3))&&((cordLex4<cordrvx4)&&(cordLex4<=(cordnx1-0.5)))&&(cordR1x1<=(cordnx1-0.27))&&(cordR2x2>=(cordpx1+0.27))
		bbox=list((cordR1x1-0.27):by1 (cordR1x3+0.04):by2))
		when(((cordR1x3>cordrvx3)&&(cordR1x3>cordLex3))&&((cordLex4<cordrvx4)&&(cordLex4<=(cordnx1-0.5)))&&(cordR1x1<=(cordnx1-0.27))&&(cordR2x2<(cordpx1+0.27))
		bbox=list((cordR1x1-0.27):by1 (cordR1x3+0.04):by2))
		when(((cordR1x3>cordrvx3)&&(cordR1x3>cordLex3))&&((cordLex4<cordrvx4)&&(cordLex4<=(cordnx1-0.5)))&&(cordR1x1>(cordnx1-0.27))&&(cordR2x2>=(cordpx1+0.27))
		bbox=list((cordLex4-0.04):by1 (cordR1x3+0.04):by2))
		when(((cordR1x3>cordrvx3)&&(cordR1x3>cordLex3))&&(((cordnx1-0.5)<cordLex4)&&((cordnx1-0.5)<=cordrvx4))&&(cordR1x1>(cordnx1-0.27))&&(cordR2x2<(cordpx1+0.27))
		bbox=list((cordnx1-0.54):by1 (cordR1x3+0.04):by2))
		when(((cordR1x3>cordrvx3)&&(cordR1x3>cordLex3))&&(((cordnx1-0.5)<cordLex4)&&((cordnx1-0.5)<=cordrvx4))&&(cordR1x1<=(cordnx1-0.27))&&(cordR2x2>=(cordpx1+0.27))
		bbox=list((cordR1x1-0.27):by1 (cordR1x3+0.04):by2))
		when(((cordR1x3>cordrvx3)&&(cordR1x3>cordLex3))&&(((cordnx1-0.5)<cordLex4)&&((cordnx1-0.5)<=cordrvx4))&&(cordR1x1<=(cordnx1-0.27))&&(cordR2x2<(cordpx1+0.27))
		bbox=list((cordR1x1-0.27):by1 (cordR1x3+0.04):by2))
		when(((cordR1x3>cordrvx3)&&(cordR1x3>cordLex3))&&(((cordnx1-0.5)<cordLex4)&&((cordnx1-0.5)<=cordrvx4))&&(cordR1x1>(cordnx1-0.27))&&(cordR2x2>=(cordpx1+0.27))
		bbox=list((cordnx1-0.54):by1 (cordR1x3+0.04):by2)))
	when((ActualLeftPoly>cordrvx4)||(ActualLeftPoly>cordLex4)
		when((cordrvx4<=cordLex4)&&(cordrvx3>=cordLex3)&&(cordrvx3>=cordR1x3)
		bbox=list((cordrvx4-0.04):by1 (cordrvx3+0.04):by2))
		when((cordrvx4<=cordLex4)&&(cordLex3>cordrvx3)&&(cordLex3>=cordR1x3)
		bbox=list((cordrvx4-0.04):by1 (cordLex3+0.04):by2))
		when((cordrvx4<=cordLex4)&&(cordR1x3>cordrvx3)&&(cordR1x3>cordLex3)
		bbox=list((cordrvx4-0.04):by1 (cordR1x3+0.04):by2))
		when((cordLex4<cordrvx4)&&(cordrvx3>=cordLex3)&&(cordrvx3>=cordR1x3)
		bbox=list((cordLex4-0.04):by1 (cordR1x3+0.04):by2))
		when((cordLex4<cordrvx4)&&(cordLex3>cordrvx3)&&(cordLex3>=cordR1x3)
		bbox=list((cordLex4-0.04):by1 (cordR1x3+0.04):by2))
		when((cordLex4<cordrvx4)&&(cordR1x3>cordrvx3)&&(cordR1x3>cordLex3)
		bbox=list((cordLex4-0.04):by1 (cordR1x3+0.04):by2)))
		LeftLeaf=caar(bbox)
		RightLeaf=caadr(bbox)-LeftLeaf
		dbSet(SHAPE bbox "bBox")); stretches M3 GND/VDD power grids
		when((SHAPE~>layerName=="NP")&&((bx1==0&&by2==0.17&&bx2==2.08)||(bx1==0&&by2==6.24&&bx2==2.08))
		when(((cordrvx3>=cordLex3)&&(cordrvx3>=cordR1x3))&&((cordrvx4<=cordLex4)&&(cordrvx4<=(cordnx1-0.5)))&&(cordR1x1>(cordnx1-0.27))&&(cordR2x2<(cordpx1+0.27))
		bbox=list((cordrvx4-0.04):by1 (cordrvx3+0.04):by2))
		when(((cordrvx3>=cordLex3)&&(cordrvx3>=cordR1x3))&&((cordrvx4<=cordLex4)&&(cordrvx4<=(cordnx1-0.5)))&&(cordR1x1<=(cordnx1-0.27))&&(cordR2x2>=(cordpx1+0.27))
		bbox=list((cordR1x1-0.27):by1 (cordrvx3+0.04):by2))
		when(((cordrvx3>=cordLex3)&&(cordrvx3>=cordR1x3))&&((cordrvx4<=cordLex4)&&(cordrvx4<=(cordnx1-0.5)))&&(cordR1x1<=(cordnx1-0.27))&&(cordR2x2<(cordpx1+0.27))
		bbox=list((cordR1x1-0.27):by1 (cordrvx3+0.04):by2))
		when(((cordrvx3>=cordLex3)&&(cordrvx3>=cordR1x3))&&((cordrvx4<=cordLex4)&&(cordrvx4<=(cordnx1-0.5)))&&(cordR1x1>(cordnx1-0.27))&&(cordR2x2>=(cordpx1+0.27))
		bbox=list((cordrvx4-0.04):by1 (cordrvx3+0.04):by2))
		when(((cordrvx3>=cordLex3)&&(cordrvx3>=cordR1x3))&&((cordLex4<cordrvx4)&&(cordLex4<=(cordnx1-0.5)))&&(cordR1x1>(cordnx1-0.27))&&(cordR2x2<(cordpx1+0.27))
		bbox=list((cordLex4-0.04):by1 (cordrvx3+0.04):by2))
		when(((cordrvx3>=cordLex3)&&(cordrvx3>=cordR1x3))&&((cordLex4<cordrvx4)&&(cordLex4<=(cordnx1-0.5)))&&(cordR1x1<=(cordnx1-0.27))&&(cordR2x2>=(cordpx1+0.27))
		bbox=list((cordR1x1-0.27):by1 (cordrvx3+0.04):by2))
		when(((cordrvx3>=cordLex3)&&(cordrvx3>=cordR1x3))&&((cordLex4<cordrvx4)&&(cordLex4<=(cordnx1-0.5)))&&(cordR1x1<=(cordnx1-0.27))&&(cordR2x2<(cordpx1+0.27))
		bbox=list((cordR1x1-0.27):by1 (cordrvx3+0.04):by2))
		when(((cordrvx3>=cordLex3)&&(cordrvx3>=cordR1x3))&&((cordLex4<cordrvx4)&&(cordLex4<=(cordnx1-0.5)))&&(cordR1x1>(cordnx1-0.27))&&(cordR2x2>=(cordpx1+0.27))
		bbox=list((cordLex4-0.04):by1 (cordrvx3+0.04):by2))
		when(((cordrvx3>=cordLex3)&&(cordrvx3>=cordR1x3))&&(((cordnx1-0.5)<cordLex4)&&((cordnx1-0.5)<=cordrvx4))&&(cordR1x1>(cordnx1-0.27))&&(cordR2x2<(cordpx1+0.27))
		bbox=list((cordnx1-0.54):by1 (cordrvx3+0.04):by2))
		when(((cordrvx3>=cordLex3)&&(cordrvx3>=cordR1x3))&&(((cordnx1-0.5)<cordLex4)&&((cordnx1-0.5)<=cordrvx4))&&(cordR1x1<=(cordnx1-0.27))&&(cordR2x2>=(cordpx1+0.27))
		bbox=list((cordR1x1-0.27):by1 (cordrvx3+0.04):by2))
		when(((cordrvx3>=cordLex3)&&(cordrvx3>=cordR1x3))&&(((cordnx1-0.5)<cordLex4)&&((cordnx1-0.5)<=cordrvx4))&&(cordR1x1<=(cordnx1-0.27))&&(cordR2x2<(cordpx1+0.27))
		bbox=list((cordR1x1-0.27):by1 (cordrvx3+0.04):by2))
		when(((cordrvx3>=cordLex3)&&(cordrvx3>=cordR1x3))&&(((cordnx1-0.5)<cordLex4)&&((cordnx1-0.5)<=cordrvx4))&&(cordR1x1>(cordnx1-0.27))&&(cordR2x2>=(cordpx1+0.27))
		bbox=list((cordnx1-0.54):by1 (cordrvx3+0.04):by2))
		when(((cordLex3>cordrvx3)&&(cordLex3>=cordR1x3))&&((cordrvx4<=cordLex4)&&(cordrvx4<=(cordnx1-0.5)))&&(cordR1x1>(cordnx1-0.27))&&(cordR2x2<(cordpx1+0.27))
		bbox=list((cordrvx4-0.04):by1 (cordLex3+0.04):by2))
		when(((cordLex3>cordrvx3)&&(cordLex3>=cordR1x3))&&((cordrvx4<=cordLex4)&&(cordrvx4<=(cordnx1-0.5)))&&(cordR1x1<=(cordnx1-0.27))&&(cordR2x2>=(cordpx1+0.27))
		bbox=list((cordR1x1-0.27):by1 (cordLex3+0.04):by2))
		when(((cordLex3>cordrvx3)&&(cordLex3>=cordR1x3))&&((cordrvx4<=cordLex4)&&(cordrvx4<=(cordnx1-0.5)))&&(cordR1x1<=(cordnx1-0.27))&&(cordR2x2<(cordpx1+0.27))
		bbox=list((cordR1x1-0.27):by1 (cordLex3+0.04):by2))
		when(((cordLex3>cordrvx3)&&(cordLex3>=cordR1x3))&&((cordrvx4<=cordLex4)&&(cordrvx4<=(cordnx1-0.5)))&&(cordR1x1>(cordnx1-0.27))&&(cordR2x2>=(cordpx1+0.27))
		bbox=list((cordrvx4-0.04):by1 (cordLex3+0.04):by2))
		when(((cordLex3>cordrvx3)&&(cordLex3>=cordR1x3))&&((cordLex4<cordrvx4)&&(cordLex4<=(cordnx1-0.5)))&&(cordR1x1>(cordnx1-0.27))&&(cordR2x2<(cordpx1+0.27))
		bbox=list((cordLex4-0.04):by1 (cordLex3+0.04):by2))
		when(((cordLex3>cordrvx3)&&(cordLex3>=cordR1x3))&&((cordLex4<cordrvx4)&&(cordLex4<=(cordnx1-0.5)))&&(cordR1x1<=(cordnx1-0.27))&&(cordR2x2>=(cordpx1+0.27))
		bbox=list((cordR1x1-0.04):by1 (cordLex3+0.04):by2))
		when(((cordLex3>cordrvx3)&&(cordLex3>=cordR1x3))&&((cordLex4<cordrvx4)&&(cordLex4<=(cordnx1-0.5)))&&(cordR1x1<=(cordnx1-0.27))&&(cordR2x2<(cordpx1+0.27))
		bbox=list((cordR1x1-0.27):by1 (cordLex3+0.04):by2))
		when(((cordLex3>cordrvx3)&&(cordLex3>=cordR1x3))&&((cordLex4<cordrvx4)&&(cordLex4<=(cordnx1-0.5)))&&(cordR1x1>(cordnx1-0.27))&&(cordR2x2>=(cordpx1+0.27))
		bbox=list((cordLex4-0.04):by1 (cordLex3+0.04):by2))
		when(((cordLex3>cordrvx3)&&(cordLex3>=cordR1x3))&&(((cordnx1-0.5)<cordLex4)&&((cordnx1-0.5)<=cordrvx4))&&(cordR1x1>(cordnx1-0.27))&&(cordR2x2<(cordpx1+0.27))
		bbox=list((cordnx1-0.54):by1 (cordLex3+0.04):by2))
		when(((cordLex3>cordrvx3)&&(cordLex3>=cordR1x3))&&(((cordnx1-0.5)<cordLex4)&&((cordnx1-0.5)<=cordrvx4))&&(cordR1x1<=(cordnx1-0.27))&&(cordR2x2>=(cordpx1+0.27))
		bbox=list((cordR1x1-0.27):by1 (cordLex3+0.04):by2))
		when(((cordLex3>cordrvx3)&&(cordLex3>=cordR1x3))&&(((cordnx1-0.5)<cordLex4)&&((cordnx1-0.5)<=cordrvx4))&&(cordR1x1<=(cordnx1-0.27))&&(cordR2x2<(cordpx1+0.27))
		bbox=list((cordR1x1-0.27):by1 (cordLex3+0.04):by2))
		when(((cordLex3>cordrvx3)&&(cordLex3>=cordR1x3))&&(((cordnx1-0.5)<cordLex4)&&((cordnx1-0.5)<=cordrvx4))&&(cordR1x1>(cordnx1-0.27))&&(cordR2x2>=(cordpx1+0.27))
		bbox=list((cordnx1-0.54):by1 (cordLex3+0.04):by2))
		when(((cordR1x3>cordrvx3)&&(cordR1x3>cordLex3))&&((cordrvx4<=cordLex4)&&(cordrvx4<=(cordnx1-0.5)))&&(cordR1x1>(cordnx1-0.27))&&(cordR2x2<(cordpx1+0.27))
		bbox=list((cordrvx4-0.04):by1 (cordR1x3+0.04):by2))
		when(((cordR1x3>cordrvx3)&&(cordR1x3>cordLex3))&&((cordrvx4<=cordLex4)&&(cordrvx4<=(cordnx1-0.5)))&&(cordR1x1<=(cordnx1-0.27))&&(cordR2x2>=(cordpx1+0.27))
		bbox=list((cordR1x1-0.27):by1 (cordR1x3+0.04):by2))
		when(((cordR1x3>cordrvx3)&&(cordR1x3>cordLex3))&&((cordrvx4<=cordLex4)&&(cordrvx4<=(cordnx1-0.5)))&&(cordR1x1<=(cordnx1-0.27))&&(cordR2x2<(cordpx1+0.27))
		bbox=list((cordR1x1-0.27):by1 (cordR1x3+0.04):by2))
		when(((cordR1x3>cordrvx3)&&(cordR1x3>cordLex3))&&((cordrvx4<=cordLex4)&&(cordrvx4<=(cordnx1-0.5)))&&(cordR1x1>(cordnx1-0.27))&&(cordR2x2>=(cordpx1+0.27))
		bbox=list((cordrvx4-0.04):by1 (cordR1x2+0.04):by2))
		when(((cordR1x3>cordrvx3)&&(cordR1x3>cordLex3))&&((cordLex4<cordrvx4)&&(cordLex4<=(cordnx1-0.5)))&&(cordR1x1>(cordnx1-0.27))&&(cordR2x2<(cordpx1+0.27))
		bbox=list((cordLex4-0.04):by1 (cordR1x3+0.04):by2))
		when(((cordR1x3>cordrvx3)&&(cordR1x3>cordLex3))&&((cordLex4<cordrvx4)&&(cordLex4<=(cordnx1-0.5)))&&(cordR1x1<=(cordnx1-0.27))&&(cordR2x2>=(cordpx1+0.27))
		bbox=list((cordR1x1-0.27):by1 (cordR1x3+0.04):by2))
		when(((cordR1x3>cordrvx3)&&(cordR1x3>cordLex3))&&((cordLex4<cordrvx4)&&(cordLex4<=(cordnx1-0.5)))&&(cordR1x1<=(cordnx1-0.27))&&(cordR2x2<(cordpx1+0.27))
		bbox=list((cordR1x1-0.27):by1 (cordR1x3+0.04):by2))
		when(((cordR1x3>cordrvx3)&&(cordR1x3>cordLex3))&&((cordLex4<cordrvx4)&&(cordLex4<=(cordnx1-0.5)))&&(cordR1x1>(cordnx1-0.27))&&(cordR2x2>=(cordpx1+0.27))
		bbox=list((cordLex4-0.04):by1 (cordR1x3+0.04):by2))
		when(((cordR1x3>cordrvx3)&&(cordR1x3>cordLex3))&&(((cordnx1-0.5)<cordLex4)&&((cordnx1-0.5)<=cordrvx4))&&(cordR1x1>(cordnx1-0.27))&&(cordR2x2<(cordpx1+0.27))
		bbox=list((cordnx1-0.54):by1 (cordR1x3+0.04):by2))
		when(((cordR1x3>cordrvx3)&&(cordR1x3>cordLex3))&&(((cordnx1-0.5)<cordLex4)&&((cordnx1-0.5)<=cordrvx4))&&(cordR1x1<=(cordnx1-0.27))&&(cordR2x2>=(cordpx1+0.27))
		bbox=list((cordR1x1-0.27):by1 (cordR1x3+0.04):by2))
		when(((cordR1x3>cordrvx3)&&(cordR1x3>cordLex3))&&(((cordnx1-0.5)<cordLex4)&&((cordnx1-0.5)<=cordrvx4))&&(cordR1x1<=(cordnx1-0.27))&&(cordR2x2<(cordpx1+0.27))
		bbox=list((cordR1x1-0.27):by1 (cordR1x3+0.04):by2))
		when(((cordR1x3>cordrvx3)&&(cordR1x3>cordLex3))&&(((cordnx1-0.5)<cordLex4)&&((cordnx1-0.5)<=cordrvx4))&&(cordR1x1>(cordnx1-0.27))&&(cordR2x2>=(cordpx1+0.27))
		bbox=list((cordnx1-0.54):by1 (cordR1x3+0.04):by2))
		dbSet(SHAPE bbox "bBox")); stretches NP layer on the top and bottom of the leaf cell
		when((SHAPE~>layerName=="PO")&&(bx1==2.04&&by2==6.24&&bx2==2.08)
		when(((cordrvx3>=cordLex3)&&(cordrvx3>=cordR1x3))
		bbox=list(cordrvx3:by1 (cordrvx3+0.04):by2))
		when(((cordLex3>cordrvx3)&&(cordLex3>=cordR1x3))
		bbox=list(cordLex3:by1 (cordLex3+0.04):by2))
		when(((cordR1x3>cordrvx3)&&(cordR1x3>cordLex3))
		bbox=list(cordR1x3:by1 (cordR1x3+0.04):by2))
		dbSet(SHAPE bbox "bBox")); moves Cut_poly on the right side of the leaf cell
		when((SHAPE~>layerName=="PO")&&(bx1==0&&by2==6.24&&bx2==0.04)
		when(((cordrvx4<=cordLex4)&&(cordrvx4<=(cordnx1-0.5))&&(cordR1x1>(cordnx1-0.27)))
		bbox=list((cordrvx4-0.04):by1 cordrvx4:by2))
		when(((cordrvx4<=cordLex4)&&(cordrvx4<=(cordnx1-0.5))&&(cordR1x1<=(cordnx1-0.27)))
		bbox=list((cordR1x1-0.23):by1 (cordR1x1-0.27):by2))
		when(((cordLex4<cordrvx4)&&(cordLex4<=(cordnx1-0.5))&&(cordR1x1>(cordnx1-0.27)))
		bbox=list((cordLex4-0.04):by1 cordLex4:by2))
		when(((cordLex4<cordrvx4)&&(cordLex4<=(cordnx1-0.5))&&(cordR1x1<=(cordnx1-0.27)))
		bbox=list((cordR1x1-0.23):by1 (cordR1x1-0.27):by2))
		when((((cordnx1-0.5)<cordLex4)&&((cordnx1-0.5)<=cordrvx4)&&(cordR1x1>(cordnx1-0.27)))
		bbox=list((cordnx1-0.54):by1 (cordnx1-0.5):by2))
		when((((cordnx1-0.5)<cordLex4)&&((cordnx1-0.5)<=cordrvx4)&&(cordR1x1<=(cordnx1-0.27)))
		bbox=list((cordR1x1-0.23):by1 (cordR1x1-0.27):by2))
		dbSet(SHAPE bbox "bBox")); moves Cut_poly on the left side of the leaf cell
		when((SHAPE~>layerName=="PO")&&((bx2==2.08&&by2==0.08&&bx1==0)||(bx2==2.08&&by2==0.21&&bx1==0)||(bx2==2.08&&by2==0.34&&bx1==0)||(bx2==2.08&&by2==0.47&&bx1==0)||(bx2==2.08&&by2==0.6&&bx1==0)||(bx2==2.08&&by2==0.73&&bx1==0)||(bx2==2.08&&by2==0.86&&bx1==0)||(bx2==2.08&&by2==0.99&&bx1==0)||(bx2==2.08&&by2==1.12&&bx1==0)||(bx2==2.08&&by2==1.25&&bx1==0)||(bx2==2.08&&by2==1.38&&bx1==0)||(bx2==2.08&&by2==1.51&&bx1==0)||(bx2==2.08&&by2==1.64&&bx1==0)||(bx2==2.08&&by2==1.77&&bx1==0)||(bx2==2.08&&by2==1.9&&bx1==0)||(bx2==2.08&&by2==2.03&&bx1==0)||(bx2==2.08&&by2==2.42&&bx1==0)||(bx2==2.08&&by2==2.55&&bx1==0)||(bx2==2.08&&by2==2.68&&bx1==0)||(bx2==2.08&&by2==2.81&&bx1==0)||(bx2==2.08&&by2==2.94&&bx1==0)||(bx2==2.08&&by2==3.07&&bx1==0)||(bx2==2.08&&by2==3.2&&bx1==0)||(bx2==2.08&&by2==3.33&&bx1==0)||(bx2==2.08&&by2==3.46&&bx1==0)||(bx2==2.08&&by2==3.59&&bx1==0)||(bx2==2.08&&by2==3.72&&bx1==0)||(bx2==2.08&&by2==3.85&&bx1==0)||(bx2==2.08&&by2==3.98&&bx1==0)||(bx2==2.08&&by2==4.11&&bx1==0)||(bx2==2.08&&by2==4.24&&bx1==0)||(bx2==2.08&&by2==4.37&&bx1==0)||(bx2==2.08&&by2==4.5&&bx1==0)||(bx2==2.08&&by2==4.63&&bx1==0)||(bx2==2.08&&by2==4.76&&bx1==0)||(bx2==2.08&&by2==4.89&&bx1==0)||(bx2==2.08&&by2==5.02&&bx1==0)||(bx2==2.08&&by2==5.15&&bx1==0)||(bx2==2.08&&by2==5.28&&bx1==0)||(bx2==2.08&&by2==5.41&&bx1==0)||(bx2==2.08&&by2==5.54&&bx1==0)||(bx2==2.08&&by2==5.67&&bx1==0)||(bx2==2.08&&by2==5.8&&bx1==0)||(bx2==2.08&&by2==5.93&&bx1==0)||(bx2==2.08&&by2==6.06&&bx1==0)||(bx2==2.08&&by2==6.19&&bx1==0))
		when(((cordrvx3>=cordLex3)&&(cordrvx3>=cordR1x3))&&((cordrvx4<=cordLex4)&&(cordrvx4<=(cordnx1-0.5)))&&(cordR1x1>(cordnx1-0.27))&&(cordR2x2<(cordpx1+0.27))
		bbox=list((cordrvx4-0.04):by1 (cordrvx3+0.04):by2))
		when(((cordrvx3>=cordLex3)&&(cordrvx3>=cordR1x3))&&((cordrvx4<=cordLex4)&&(cordrvx4<=(cordnx1-0.5)))&&(cordR1x1<=(cordnx1-0.27))&&(cordR2x2>=(cordpx1+0.27))
		bbox=list((cordR1x1-0.27):by1 (cordrvx3+0.04):by2))
		when(((cordrvx3>=cordLex3)&&(cordrvx3>=cordR1x3))&&((cordrvx4<=cordLex4)&&(cordrvx4<=(cordnx1-0.5)))&&(cordR1x1<=(cordnx1-0.27))&&(cordR2x2<(cordpx1+0.27))
		bbox=list((cordR1x1-0.27):by1 (cordrvx3+0.04):by2))
		when(((cordrvx3>=cordLex3)&&(cordrvx3>=cordR1x3))&&((cordrvx4<=cordLex4)&&(cordrvx4<=(cordnx1-0.5)))&&(cordR1x1>(cordnx1-0.27))&&(cordR2x2>=(cordpx1+0.27))
		bbox=list((cordrvx4-0.04):by1 (cordrvx3+0.04):by2))
		when(((cordrvx3>=cordLex3)&&(cordrvx3>=cordR1x3))&&((cordLex4<cordrvx4)&&(cordLex4<=(cordnx1-0.5)))&&(cordR1x1>(cordnx1-0.27))&&(cordR2x2<(cordpx1+0.27))
		bbox=list((cordLex4-0.04):by1 (cordrvx3+0.04):by2))
		when(((cordrvx3>=cordLex3)&&(cordrvx3>=cordR1x3))&&((cordLex4<cordrvx4)&&(cordLex4<=(cordnx1-0.5)))&&(cordR1x1<=(cordnx1-0.27))&&(cordR2x2>=(cordpx1+0.27))
		bbox=list((cordR1x1-0.27):by1 (cordrvx3+0.04):by2))
		when(((cordrvx3>=cordLex3)&&(cordrvx3>=cordR1x3))&&((cordLex4<cordrvx4)&&(cordLex4<=(cordnx1-0.5)))&&(cordR1x1<=(cordnx1-0.27))&&(cordR2x2<(cordpx1+0.27))
		bbox=list((cordR1x1-0.27):by1 (cordrvx3+0.04):by2))
		when(((cordrvx3>=cordLex3)&&(cordrvx3>=cordR1x3))&&((cordLex4<cordrvx4)&&(cordLex4<=(cordnx1-0.5)))&&(cordR1x1>(cordnx1-0.27))&&(cordR2x2>=(cordpx1+0.27))
		bbox=list((cordLex4-0.04):by1 (cordrvx3+0.04):by2))
		when(((cordrvx3>=cordLex3)&&(cordrvx3>=cordR1x3))&&(((cordnx1-0.5)<cordLex4)&&((cordnx1-0.5)<=cordrvx4))&&(cordR1x1>(cordnx1-0.27))&&(cordR2x2<(cordpx1+0.27))
		bbox=list((cordnx1-0.54):by1 (cordrvx3+0.04):by2))
		when(((cordrvx3>=cordLex3)&&(cordrvx3>=cordR1x3))&&(((cordnx1-0.5)<cordLex4)&&((cordnx1-0.5)<=cordrvx4))&&(cordR1x1<=(cordnx1-0.27))&&(cordR2x2>=(cordpx1+0.27))
		bbox=list((cordR1x1-0.27):by1 (cordrvx3+0.04):by2))
		when(((cordrvx3>=cordLex3)&&(cordrvx3>=cordR1x3))&&(((cordnx1-0.5)<cordLex4)&&((cordnx1-0.5)<=cordrvx4))&&(cordR1x1<=(cordnx1-0.27))&&(cordR2x2<(cordpx1+0.27))
		bbox=list((cordR1x1-0.27):by1 (cordrvx3+0.04):by2))
		when(((cordrvx3>=cordLex3)&&(cordrvx3>=cordR1x3))&&(((cordnx1-0.5)<cordLex4)&&((cordnx1-0.5)<=cordrvx4))&&(cordR1x1>(cordnx1-0.27))&&(cordR2x2>=(cordpx1+0.27))
		bbox=list((cordnx1-0.54):by1 (cordrvx3+0.04):by2))
		when(((cordLex3>cordrvx3)&&(cordLex3>=cordR1x3))&&((cordrvx4<=cordLex4)&&(cordrvx4<=(cordnx1-0.5)))&&(cordR1x1>(cordnx1-0.27))&&(cordR2x2<(cordpx1+0.27))
		bbox=list((cordrvx4-0.04):by1 (cordLex3+0.04):by2))
		when(((cordLex3>cordrvx3)&&(cordLex3>=cordR1x3))&&((cordrvx4<=cordLex4)&&(cordrvx4<=(cordnx1-0.5)))&&(cordR1x1<=(cordnx1-0.27))&&(cordR2x2>=(cordpx1+0.27))
		bbox=list((cordR1x1-0.27):by1 (cordLex3+0.04):by2))
		when(((cordLex3>cordrvx3)&&(cordLex3>=cordR1x3))&&((cordrvx4<=cordLex4)&&(cordrvx4<=(cordnx1-0.5)))&&(cordR1x1<=(cordnx1-0.27))&&(cordR2x2<(cordpx1+0.27))
		bbox=list((cordR1x1-0.27):by1 (cordLex3+0.04):by2))
		when(((cordLex3>cordrvx3)&&(cordLex3>=cordR1x3))&&((cordrvx4<=cordLex4)&&(cordrvx4<=(cordnx1-0.5)))&&(cordR1x1>(cordnx1-0.27))&&(cordR2x2>=(cordpx1+0.27))
		bbox=list((cordrvx4-0.04):by1 (cordLex3+0.04):by2))
		when(((cordLex3>cordrvx3)&&(cordLex3>=cordR1x3))&&((cordLex4<cordrvx4)&&(cordLex4<=(cordnx1-0.5)))&&(cordR1x1>(cordnx1-0.27))&&(cordR2x2<(cordpx1+0.27))
		bbox=list((cordLex4-0.04):by1 (cordLex3+0.04):by2))
		when(((cordLex3>cordrvx3)&&(cordLex3>=cordR1x3))&&((cordLex4<cordrvx4)&&(cordLex4<=(cordnx1-0.5)))&&(cordR1x1<=(cordnx1-0.27))&&(cordR2x2>=(cordpx1+0.27))
		bbox=list((cordR1x1-0.04):by1 (cordLex3+0.04):by2))
		when(((cordLex3>cordrvx3)&&(cordLex3>=cordR1x3))&&((cordLex4<cordrvx4)&&(cordLex4<=(cordnx1-0.5)))&&(cordR1x1<=(cordnx1-0.27))&&(cordR2x2<(cordpx1+0.27))
		bbox=list((cordR1x1-0.27):by1 (cordLex3+0.04):by2))
		when(((cordLex3>cordrvx3)&&(cordLex3>=cordR1x3))&&((cordLex4<cordrvx4)&&(cordLex4<=(cordnx1-0.5)))&&(cordR1x1>(cordnx1-0.27))&&(cordR2x2>=(cordpx1+0.27))
		bbox=list((cordLex4-0.04):by1 (cordLex3+0.04):by2))
		when(((cordLex3>cordrvx3)&&(cordLex3>=cordR1x3))&&(((cordnx1-0.5)<cordLex4)&&((cordnx1-0.5)<=cordrvx4))&&(cordR1x1>(cordnx1-0.27))&&(cordR2x2<(cordpx1+0.27))
		bbox=list((cordnx1-0.54):by1 (cordLex3+0.04):by2))
		when(((cordLex3>cordrvx3)&&(cordLex3>=cordR1x3))&&(((cordnx1-0.5)<cordLex4)&&((cordnx1-0.5)<=cordrvx4))&&(cordR1x1<=(cordnx1-0.27))&&(cordR2x2>=(cordpx1+0.27))
		bbox=list((cordR1x1-0.27):by1 (cordLex3+0.04):by2))
		when(((cordLex3>cordrvx3)&&(cordLex3>=cordR1x3))&&(((cordnx1-0.5)<cordLex4)&&((cordnx1-0.5)<=cordrvx4))&&(cordR1x1<=(cordnx1-0.27))&&(cordR2x2<(cordpx1+0.27))
		bbox=list((cordR1x1-0.27):by1 (cordLex3+0.04):by2))
		when(((cordLex3>cordrvx3)&&(cordLex3>=cordR1x3))&&(((cordnx1-0.5)<cordLex4)&&((cordnx1-0.5)<=cordrvx4))&&(cordR1x1>(cordnx1-0.27))&&(cordR2x2>=(cordpx1+0.27))
		bbox=list((cordnx1-0.54):by1 (cordLex3+0.04):by2))
		when(((cordR1x3>cordrvx3)&&(cordR1x3>cordLex3))&&((cordrvx4<=cordLex4)&&(cordrvx4<=(cordnx1-0.5)))&&(cordR1x1>(cordnx1-0.27))&&(cordR2x2<(cordpx1+0.27))
		bbox=list((cordrvx4-0.04):by1 (cordR1x3+0.04):by2))
		when(((cordR1x3>cordrvx3)&&(cordR1x3>cordLex3))&&((cordrvx4<=cordLex4)&&(cordrvx4<=(cordnx1-0.5)))&&(cordR1x1<=(cordnx1-0.27))&&(cordR2x2>=(cordpx1+0.27))
		bbox=list((cordR1x1-0.27):by1 (cordR1x3+0.04):by2))
		when(((cordR1x3>cordrvx3)&&(cordR1x3>cordLex3))&&((cordrvx4<=cordLex4)&&(cordrvx4<=(cordnx1-0.5)))&&(cordR1x1<=(cordnx1-0.27))&&(cordR2x2<(cordpx1+0.27))
		bbox=list((cordR1x1-0.27):by1 (cordR1x3+0.04):by2))
		when(((cordR1x3>cordrvx3)&&(cordR1x3>cordLex3))&&((cordrvx4<=cordLex4)&&(cordrvx4<=(cordnx1-0.5)))&&(cordR1x1>(cordnx1-0.27))&&(cordR2x2>=(cordpx1+0.27))
		bbox=list((cordrvx4-0.04):by1 (cordR1x2+0.04):by2))
		when(((cordR1x3>cordrvx3)&&(cordR1x3>cordLex3))&&((cordLex4<cordrvx4)&&(cordLex4<=(cordnx1-0.5)))&&(cordR1x1>(cordnx1-0.27))&&(cordR2x2<(cordpx1+0.27))
		bbox=list((cordLex4-0.04):by1 (cordR1x3+0.04):by2))
		when(((cordR1x3>cordrvx3)&&(cordR1x3>cordLex3))&&((cordLex4<cordrvx4)&&(cordLex4<=(cordnx1-0.5)))&&(cordR1x1<=(cordnx1-0.27))&&(cordR2x2>=(cordpx1+0.27))
		bbox=list((cordR1x1-0.27):by1 (cordR1x3+0.04):by2))
		when(((cordR1x3>cordrvx3)&&(cordR1x3>cordLex3))&&((cordLex4<cordrvx4)&&(cordLex4<=(cordnx1-0.5)))&&(cordR1x1<=(cordnx1-0.27))&&(cordR2x2<(cordpx1+0.27))
		bbox=list((cordR1x1-0.27):by1 (cordR1x3+0.04):by2))
		when(((cordR1x3>cordrvx3)&&(cordR1x3>cordLex3))&&((cordLex4<cordrvx4)&&(cordLex4<=(cordnx1-0.5)))&&(cordR1x1>(cordnx1-0.27))&&(cordR2x2>=(cordpx1+0.27))
		bbox=list((cordLex4-0.04):by1 (cordR1x3+0.04):by2))
		when(((cordR1x3>cordrvx3)&&(cordR1x3>cordLex3))&&(((cordnx1-0.5)<cordLex4)&&((cordnx1-0.5)<=cordrvx4))&&(cordR1x1>(cordnx1-0.27))&&(cordR2x2<(cordpx1+0.27))
		bbox=list((cordnx1-0.54):by1 (cordR1x3+0.04):by2))
		when(((cordR1x3>cordrvx3)&&(cordR1x3>cordLex3))&&(((cordnx1-0.5)<cordLex4)&&((cordnx1-0.5)<=cordrvx4))&&(cordR1x1<=(cordnx1-0.27))&&(cordR2x2>=(cordpx1+0.27))
		bbox=list((cordR1x1-0.27):by1 (cordR1x3+0.04):by2))
		when(((cordR1x3>cordrvx3)&&(cordR1x3>cordLex3))&&(((cordnx1-0.5)<cordLex4)&&((cordnx1-0.5)<=cordrvx4))&&(cordR1x1<=(cordnx1-0.27))&&(cordR2x2<(cordpx1+0.27))
		bbox=list((cordR1x1-0.27):by1 (cordR1x3+0.04):by2))
		when(((cordR1x3>cordrvx3)&&(cordR1x3>cordLex3))&&(((cordnx1-0.5)<cordLex4)&&((cordnx1-0.5)<=cordrvx4))&&(cordR1x1>(cordnx1-0.27))&&(cordR2x2>=(cordpx1+0.27))
		bbox=list((cordnx1-0.54):by1 (cordR1x3+0.04):by2))
		dbSet(SHAPE bbox "bBox")) ; stretches the dummy poly grids to the pr bound
		when((SHAPE~>layerName=="PO")&&((bx2==1.82&&by2==2.16&&bx1==0.425)||(bx2==1.82&&by2==2.29&&bx1==0.425))
		when(((cordrvx3>=cordLex3)&&(cordrvx3>=cordR1x3))&&((cordrvx4<=cordLex4)&&(cordrvx4<=(cordnx1-0.5)))&&(cordR1x1>(cordnx1-0.27))
		bbox=list((cordrvx4+0.22):by1 (cordrvx3-0.22):by2))
		when(((cordrvx3>=cordLex3)&&(cordrvx3>=cordR1x3))&&((cordrvx4<=cordLex4)&&(cordrvx4<=(cordnx1-0.5)))&&(cordR1x1<=(cordnx1-0.27))
		bbox=list((cordR1x1-0.01):by1 (cordrvx3-0.22):by2))
		when(((cordrvx3>=cordLex3)&&(cordrvx3>=cordR1x3))&&((cordLex4<cordrvx4)&&(cordLex4<=(cordnx1-0.5)))&&(cordR1x1>(cordnx1-0.27))
		bbox=list((cordLex4+0.22):by1 (cordrvx3-0.22):by2))
		when(((cordrvx3>=cordLex3)&&(cordrvx3>=cordR1x3))&&((cordLex4<cordrvx4)&&(cordLex4<=(cordnx1-0.5)))&&(cordR1x1<=(cordnx1-0.27))
		bbox=list((cordR1x1-0.01):by1 (cordrvx3-0.22):by2))
		when(((cordrvx3>=cordLex3)&&(cordrvx3>=cordR1x3))&&(((cordnx1-0.5)<cordLex4)&&((cordnx1-0.5)<=cordrvx4))&&(cordR1x1>(cordnx1-0.27))
		bbox=list((cordnx1-0.28):by1 (cordrvx3-0.22):by2))
		when(((cordrvx3>=cordLex3)&&(cordrvx3>=cordR1x3))&&(((cordnx1-0.5)<cordLex4)&&((cordnx1-0.5)<=cordrvx4))&&(cordR1x1<=(cordnx1-0.27))
		bbox=list((cordR1x1-0.01):by1 (cordrvx3-0.22):by2))
		when(((cordLex3>cordrvx3)&&(cordLex3>=cordR1x3))&&((cordrvx4<=cordLex4)&&(cordrvx4<=(cordnx1-0.5)))&&(cordR1x1>(cordnx1-0.27))
		bbox=list((cordrvx4+0.22):by1 (cordLex3-0.22):by2))
		when(((cordLex3>cordrvx3)&&(cordLex3>=cordR1x3))&&((cordrvx4<=cordLex4)&&(cordrvx4<=(cordnx1-0.5)))&&(cordR1x1<=(cordnx1-0.27))
		bbox=list((cordR1x1-0.01):by1 (cordLex3-0.22):by2))
		when(((cordLex3>cordrvx3)&&(cordLex3>=cordR1x3))&&((cordLex4<cordrvx4)&&(cordLex4<=(cordnx1-0.5)))&&(cordR1x1>(cordnx1-0.27))
		bbox=list((cordLex4+0.22):by1 (cordLex3-0.22):by2))
		when(((cordLex3>cordrvx3)&&(cordLex3>=cordR1x3))&&((cordLex4<cordrvx4)&&(cordLex4<=(cordnx1-0.5)))&&(cordR1x1<=(cordnx1-0.27))
		bbox=list((cordR1x1-0.01):by1 (cordLex3-0.22):by2))
		when(((cordLex3>cordrvx3)&&(cordLex3>=cordR1x3))&&(((cordnx1-0.5)<cordLex4)&&((cordnx1-0.5)<=cordrvx4))&&(cordR1x1>(cordnx1-0.27))
		bbox=list((cordnx1-0.28):by1 (cordLex3-0.22):by2))
		when(((cordLex3>cordrvx3)&&(cordLex3>=cordR1x3))&&(((cordnx1-0.5)<cordLex4)&&((cordnx1-0.5)<=cordrvx4))&&(cordR1x1<=(cordnx1-0.27))
		bbox=list((cordR1x1-0.01):by1 (cordLex3-0.22):by2))
		when(((cordR1x3>cordrvx3)&&(cordR1x3>cordLex3))&&((cordrvx4<=cordLex4)&&(cordrvx4<=(cordnx1-0.5)))&&(cordR1x1>(cordnx1-0.27))
		bbox=list((cordrvx4+0.22):by1 (cordR1x3-0.22):by2))
		when(((cordR1x3>cordrvx3)&&(cordR1x3>cordLex3))&&((cordrvx4<=cordLex4)&&(cordrvx4<=(cordnx1-0.5)))&&(cordR1x1<=(cordnx1-0.27))
		bbox=list((cordR1x1-0.01):by1 (cordR1x3-0.22):by2))
		when(((cordR1x3>cordrvx3)&&(cordR1x3>cordLex3))&&((cordLex4<cordrvx4)&&(cordLex4<=(cordnx1-0.5)))&&(cordR1x1>(cordnx1-0.27))
		bbox=list((cordLex4+0.22):by1 (cordR1x3-0.22):by2))
		when(((cordR1x3>cordrvx3)&&(cordR1x3>cordLex3))&&((cordLex4<cordrvx4)&&(cordLex4<=(cordnx1-0.5)))&&(cordR1x1<=(cordnx1-0.27))
		bbox=list((cordR1x1-0.01):by1 (cordR1x3-0.22):by2))
		when(((cordR1x3>cordrvx3)&&(cordR1x3>cordLex3))&&(((cordnx1-0.5)<cordLex4)&&((cordnx1-0.5)<=cordrvx4))&&(cordR1x1>(cordnx1-0.27))
		bbox=list((cordnx1-0.28):by1 (cordR1x3-0.22):by2))
		when(((cordR1x3>cordrvx3)&&(cordR1x3>cordLex3))&&(((cordnx1-0.5)<cordLex4)&&((cordnx1-0.5)<=cordrvx4))&&(cordR1x1<=(cordnx1-0.27))
		bbox=list((cordR1x1-0.01):by1 (cordR1x3-0.22):by2))
		dbSet(SHAPE bbox "bBox")) ; stretches the 2 dummy poly grids to the pr bound near the PLUGS
		when((SHAPE~>layerName=="PP")&&(bx1==0&&by2==2.38&&bx2==0.05)
		when(((cordrvx4<=cordLex4)&&(cordrvx4<=(cordnx1-0.5)))&&(cordR1x1>(cordnx1-0.27))
		bbox=list((cordrvx4-0.04):by1 (cordrvx4+0.01):by2))
		when(((cordrvx4<=cordLex4)&&(cordrvx4<=(cordnx1-0.5)))&&(cordR1x1<=(cordnx1-0.27))
		bbox=list((cordR1x1-0.27):by1 (cordR1x1-0.22):by2))
		when(((cordLex4<cordrvx4)&&(cordLex4<=(cordnx1-0.5)))&&(cordR1x1>(cordnx1-0.27))
		bbox=list((cordLex4-0.04):by1 (cordLex4+0.01):by2))
		when(((cordLex4<cordrvx4)&&(cordLex4<=(cordnx1-0.5)))&&(cordR1x1<=(cordnx1-0.27))
		bbox=list((cordR1x1-0.27):by1 (cordR1x1-0.22):by2))
		when((((cordnx1-0.5)<cordLex4)&&((cordnx1-0.5)<=cordrvx4))&&(cordR1x1>(cordnx1-0.27))
		bbox=list((cordnx1-0.54):by1 (cordnx1-0.49):by2))
		when((((cordnx1-0.5)<cordLex4)&&((cordnx1-0.5)<=cordrvx4))&&(cordR1x1<=(cordnx1-0.27))
		bbox=list((cordR1x1-0.27):by1 (cordR1x1-0.22):by2))
		dbSet(SHAPE bbox "bBox")); moves PP on the left side of the NPLUG
		when((SHAPE~>layerName=="NP")&&(bx1==1.99&&by2==2.355&&bx2==2.08)
		when(((cordrvx3>=cordLex3)&&(cordrvx3>=cordR1x3))
		bbox=list((cordrvx3-0.05):by1 (cordrvx3+0.04):by2))
		when(((cordLex3>cordrvx3)&&(cordLex3>=cordR1x3))
		bbox=list((cordLex3-0.05):by1 (cordLex3+0.04):by2))
		when(((cordR1x3>cordrvx3)&&(cordR1x3>cordLex3))
		bbox=list((cordR1x3-0.05):by1 (cordR1x3+0.04):by2))
		dbSet(SHAPE bbox "bBox")); moves NP on the right side of the PPLUG
		when((SHAPE~>layerName=="NP")&&(by1==0.17&&by2==6.07)
		when(((cordrvx4<=cordLex4)&&(cordrvx4<=(cordnx1-0.5)))&&(cordR1x1>(cordnx1-0.27))
		pnts=list(x1:y1 (cordrvx4-0.04):y2 (cordrvx4-0.04):y3 (cordrvx4+0.22):y4 (cordrvx4+0.22):y5 (cordrvx4-0.04):y6 (cordrvx4-0.04):y7 x8:y8))
		when(((cordrvx4<=cordLex4)&&(cordrvx4<=(cordnx1-0.5)))&&(cordR1x1<=(cordnx1-0.27))
		pnts=list(x1:y1 (cordR1x1-0.27):y2 (cordR1x1-0.27):y3 (cordR1x1-0.01):y4 (cordR1x1-0.01):y5 (cordR1x1-0.27):y6 (cordR1x1-0.27):y7 x8:y8))
		when(((cordLex4<cordrvx4)&&(cordLex4<=(cordnx1-0.5)))&&(cordR1x1>(cordnx1-0.27))
		pnts=list(x1:y1 (cordLex4-0.04):y2 (cordLex4-0.04):y3 (cordLex4+0.22):y4 (cordLex4+0.22):y5 (cordLex4-0.04):y6 (cordLex4-0.04):y7 x8:y8))
		when(((cordLex4<cordrvx4)&&(cordLex4<=(cordnx1-0.5)))&&(cordR1x1<=(cordnx1-0.27))
		pnts=list(x1:y1 (cordR1x1-0.27):y2 (cordR1x1-0.27):y3 (cordR1x1-0.01):y4 (cordR1x1-0.01):y5 (cordR1x1-0.27):y6 (cordR1x1-0.27):y7 x8:y8))
		when((((cordnx1-0.5)<cordLex4)&&((cordnx1-0.5)<=cordrvx4))&&(cordR1x1>(cordnx1-0.27))
		pnts=list(x1:y1 (cordnx1-0.54):y2 (cordnx1-0.54):y3 (cordnx1-0.28):y4 (cordnx1-0.28):y5 (cordnx1-0.54):y6 (cordnx1-0.54):y7 x8:y8))
		when((((cordnx1-0.5)<cordLex4)&&((cordnx1-0.5)<=cordrvx4))&&(cordR1x1<=(cordnx1-0.27))
		pnts=list(x1:y1 (cordR1x1-0.27):y2 (cordR1x1-0.27):y3 (cordR1x1-0.01):y4 (cordR1x1-0.01):y5 (cordR1x1-0.27):y6 (cordR1x1-0.27):y7 x8:y8))
		dbSet(SHAPE pnts "points")) ;moves NP
		when((SHAPE~>layerName=="PP")&&(by1==0.17&&by2==6.07)
		when(((cordrvx3>=cordLex3)&&(cordrvx3>=cordR1x3))
		pnts=list((cordrvx3+0.04):y1 (cordrvx3-0.22):y2 (cordrvx3-0.22):y3 (cordrvx3+0.04):y4 (cordrvx3+0.04):y5 x6:y6 x7:y7 (cordrvx3+0.04):y8))
		when(((cordLex3>cordrvx3)&&(cordLex3>=cordR1x3))
		pnts=list((cordLex3+0.04):y1 (cordLex3-0.22):y2 (cordLex3-0.22):y3 (cordLex3+0.04):y4 (cordLex3+0.04):y5 x6:y6 x7:y7 (cordLex3+0.04):y8))
		when(((cordR1x3>cordrvx3)&&(cordR1x3>cordLex3))
		pnts=list((cordR1x3+0.04):y1 (cordR1x3-0.22):y2 (cordR1x3-0.22):y3 (cordR1x3+0.04):y4 (cordR1x3+0.04):y5 x6:y6 x7:y7 (cordR1x3+0.04):y8))
		dbSet(SHAPE pnts "points")) ;moves PP
		when(((SHAPE~>layerName=="NW")||(SHAPE~>layerName=="PM"))&&(by1==0.13&&by2==6.11)
		when(((cordrvx3>=cordLex3)&&(cordrvx3>=cordR1x3))
		bbox=list(bx1:by1 (cordrvx3+0.04):by2))
		when(((cordLex3>cordrvx3)&&(cordLex3>=cordR1x3))
		bbox=list(bx1:by1 (cordLex3+0.04):by2))
		when(((cordR1x3>cordrvx3)&&(cordR1x3>cordLex3))
		bbox=list(bx1:by1 (cordR1x3+0.04):by2))
		dbSet(SHAPE bbox "bBox")) ; stretches NW
		))

	foreach(VIA CellView->vias
		(let (vx1 vy1 bx1 by1 bx2 by2 vx1 vy1 orgn)
		bx1=caar(VIA~>bBox)
		by1=cadar(VIA~>bBox)
		bx2=caadr(VIA~>bBox)
		by2=cadadr(VIA~>bBox)
		vx1=car(VIA~>origin)
		vy1=cadr(VIA~>origin)
		when((VIA~>viaHeader~>viaDefName=="M2_M1")&& ((VIA~>net~>name=="_r.3")||(VIA~>net~>name=="_r.1"))&&((vx1==1.39)||(vx1==1.395))
		orgn=(Lpinx+0.38:vy1)
		dbSet(VIA orgn "origin"))
		when((VIA~>viaHeader~>viaDefName=="M2_M1")&& (VIA~>net~>name=="_r.3")&&(vx1==2.01)
		when((cordR2x2<(cordpx1+0.27))
		orgn=(cordpx1+0.56:vy1))
		when((cordR2x2>=(cordpx1+0.27))
		orgn=(cordR2x2+0.285:vy1))
		dbSet(VIA orgn "origin"))
		when((VIA~>viaHeader~>viaDefName=="M2_M1")&&(VIA~>net~>name=="_r.1")&&(vx1==2.01)
		when((cordR2x2<(cordpx1+0.27))&&((cordR2x2+0.285)>=(cordrvx3-0.24))
		orgn=(cordpx1+0.56:vy1))
		when((cordR2x2<(cordpx1+0.27))&&((cordR2x2+0.285)<(cordrvx3-0.24))
		orgn=(cordpx1+0.56:(vy1+0.65)))
		when((cordR2x2>=(cordpx1+0.27))&&((cordR2x2+0.285)>=(cordrvx3-0.24))
		orgn=(cordR2x2+0.285:vy1))
		when((cordR2x2>=(cordpx1+0.27))&&((cordR2x2+0.285)<(cordrvx3-0.24))
		orgn=(cordR2x2+0.285:(vy1+0.65)))
		dbSet(VIA orgn "origin"))
		when((VIA~>viaHeader~>viaDefName=="M2_M1")&& (VIA~>net~>name=="_r.2")&&(vx1==0.18)
		when((cordR1x1>(cordnx1-0.27))
		orgn=(cordnx1-0.43:vy1))
		when((cordR1x1<=(cordnx1-0.27))
		orgn=(cordR1x1-0.16:vy1))
		dbSet(VIA orgn "origin"))
		when((VIA~>viaHeader~>viaDefName=="M2_M1")&& (VIA~>net~>name=="_r.0")&&(vx1==0.46)
		orgn=(cordnx1-0.16:vy1)
		dbSet(VIA orgn "origin"))
		when(((VIA~>viaHeader~>viaDefName=="M2_M1")||(VIA~>viaHeader~>viaDefName=="M3_M2"))&& ((VIA~>net~>name=="R.2")||(VIA~>net~>name=="R.1")||(VIA~>net~>name=="R.0"))&&(vx1==1.88)
		when((cordR2x2<(cordpx1+0.27))
		orgn=(cordpx1+0.43:vy1))
		when((cordR2x2>=(cordpx1+0.27))
		orgn=(cordR2x2+0.155:vy1))
		dbSet(VIA orgn "origin"))
		when(((VIA~>viaHeader~>viaDefName=="M2_M1")||(VIA~>viaHeader~>viaDefName=="M3_M2"))&& (VIA~>net~>name=="R.e")&&(vx1==1.75)
		when((cordR2x2<(cordpx1+0.27))
		orgn=(cordpx1+0.3:vy1))
		when((cordR2x2>=(cordpx1+0.27))
		orgn=(cordR2x2+0.025:vy1))
		dbSet(VIA orgn "origin"))
		when(((VIA~>viaHeader~>viaDefName=="M2_M1")||(VIA~>viaHeader~>viaDefName=="M3_M2"))&& (VIA~>net~>name=="R.3")&&(vx1==1.63)
		when((cordR2x2<(cordpx1+0.27))
		orgn=(cordpx1+0.17:vy1))
		when((cordR2x2>=(cordpx1+0.27))
		orgn=(cordR2x2-0.105:vy1))
		dbSet(VIA orgn "origin"))
		when(((VIA~>viaHeader~>viaDefName=="M2_M1")||(VIA~>viaHeader~>viaDefName=="M3_M2"))&& (VIA~>net~>name=="_RESET")&&(vx1==1.445)
		when((cordR2x2<(cordpx1+0.27))
		orgn=(cordpx1+0.04:vy1))
		when((cordR2x2>=(cordpx1+0.27))
		orgn=(cordR2x2-0.235:vy1))
		dbSet(VIA orgn "origin"))
		when(((VIA~>viaHeader~>viaDefName=="M2_M1")||(VIA~>viaHeader~>viaDefName=="M3_M2"))&& ((VIA~>net~>name=="L.3")||(VIA~>net~>name=="L.2")||(VIA~>net~>name=="L.1")||(VIA~>net~>name=="L.0"))&&(vx1==0.33)
		when((cordR1x1>(cordnx1-0.27))
		orgn=(cordnx1-0.29:vy1))
		when((cordR1x1<=(cordnx1-0.27))
		orgn=(cordR1x1-0.02:vy1))
		dbSet(VIA orgn "origin"))
		when((VIA~>viaHeader~>viaDefName=="M2_M1")&& (VIA~>net~>name=="L.e")&&(vy1==4.16)&&(cordLey2!=4.25)
		dbDeleteObject(VIA))
		))

))

;;;;;;;;;;;;;;;;;;;;;;;;;;;;;;*****************************************************;;;;;;;;;;;;;;;;;;;;;;;;;;;;;;*****************************************************;;;;;;;;;;;;;;;;;;;;;;;;;;;;;;
;;;;;;;;;;;;;;;;;;;;;;;;;;;;;;*****************************************************;;;;;;;;;;;;;;;;;;;;;;;;;;;;;;*****************************************************;;;;;;;;;;;;;;;;;;;;;;;;;;;;;;

(defun MakeBuffer2 (CellView ViewName)
	(let ( fil text k i parameter1 parameter2 parameter3 parameter4 cordM2_M1 INST SHAPE cordnx1 cordnx2 cordleftr3Px cordrightr3Px cordleftR3Px cordnr3x1 cordnr3x2 cordpx1 cordpx2 NWidth PWidth LePWidth ResPWidth cordnx1 cordnx2 cordpx1 cordpx2 cordR0y2 cordR0y1 cordR2x1 cordR2x2 cordR2x3 cordR2x4 cordR2y2 cordR1x1 cordR1x2 cordR1x3 cordR1x4 cordR1y1 cordR1y2 p_contt cordResx2 cordresx1 cordLex1 cordLex2 cordLey2 NR1Width Nr3Width Nr2Width NR3Width PR3Width Pr3Width ixy1 ixy2 a b Actualr2x ActualL2x Actualr1x ActualR3x cordrvNPx1 cordrvNPx2 cordrvPPx1 cordrvPPx2 cordr3NPx2 cordr3NPx1 cordr3PPx2 cordr3PPx1 cordR3NPx2 rightpoly leftNPLUG rightNPLUG)
	k = 0
	i = 0
	fil = infile("Parameter.txt")
	while( gets(k fil) != nil
  	text = parseString( k " \n")
	parameter1 = nth(0 text)
	parameter2 = nth(1 text)
	parameter3 = nth(2 text)
	parameter4 = nth(3 text)
 ;setting instance parameters as per the spec file
	foreach(INST CellView->instances
		(let (N P Nparam Pparam paraN1 paraN2 paraP1 paraP2 paraP3 paraP4 paraP5 paraP6 paraP7 paraP8 paraP9 paraP10)
		when( (INST->name==parameter1) && (INST->cellName=="gate.INV.0-L1_1-R")
		N=evalstring(parameter3)
		Nparam=N/1000000
		P=evalstring(parameter4)
		Pparam=P/1000000
		when((INST->cellName=="gate.INV.0-L1_1-R") && (INST->name=="R.0")
			NWidth=N)
		when((INST->cellName=="gate.INV.0-L1_1-R") && (INST->name=="R.1")
			NR1Width=N
			PWidth=P)
		when((INST->cellName=="gate.INV.0-L1_1-R") && (INST->name=="R.3")
			NR3Width=N
			PR3Width=P)
		when((INST->cellName=="gate.INV.0-L1_1-R") && (INST->name=="L.e")
			LePWidth=P)
		when((INST->cellName=="gate.INV.0-L1_1-R") && (INST->name=="Reset")
			ResPWidth=P)
		dbReplaceProp(INST "NW1" "float" Nparam)
		dbReplaceProp(INST "PW1" "float" Pparam)
		)
		when( ( (INST->cellName=="stack.NMOS_CHAIN_2.0-L1-R") || (INST->cellName=="stack.NMOS_CHAIN_5.0-L1-R") || (INST->cellName=="stack.PMOS_CHAIN_2.0-L1-R") || (INST->cellName=="stack.PMOS_CHAIN_1.0-L1-R"))
		paraN1 = strcat( parameter1 "." "N1")
		paraN2 = strcat( parameter1 "." "N2")
		paraP1 = strcat( parameter1 "." "P1")
		paraP2 = strcat( parameter1 "." "P2")
		paraP3 = strcat( parameter1 "." "P3")
		paraP4 = strcat( parameter1 "." "P4")
		paraP5 = strcat( parameter1 "." "P5")
		paraP6 = strcat( parameter1 "." "P6")
		paraP7 = strcat( parameter1 "." "P7")
		paraP8 = strcat( parameter1 "." "P8")
		paraP9 = strcat( parameter1 "." "P9")
		paraP10 = strcat( parameter1 "." "P10")
		when(((INST->name==paraN1) || (INST->name==paraP1) || (INST->name==paraN2) || (INST->name==paraP2) || (INST->name==paraP3) || (INST->name==paraP4) || (INST->name==paraP5) || (INST->name==paraP6) || (INST->name==paraP7) || (INST->name==paraP8) || (INST->name==paraP9) || (INST->name==paraP10))
		N=evalstring(parameter3)
		Nparam=N/2000000
		P=evalstring(parameter4)
		Pparam=P/2000000
		dbReplaceProp(INST "NW2" "float" Nparam)
		dbReplaceProp(INST "NW5" "float" Nparam)
		dbReplaceProp(INST "PW2" "float" Pparam)
		dbReplaceProp(INST "PW1" "float" Pparam)
		when(((INST->cellName=="stack.NMOS_CHAIN_2.0-L1-R") && (INST->name=="_r.3.N1"))
		Nr3Width=N)
		when(((INST->cellName=="stack.NMOS_CHAIN_2.0-L1-R") && (INST->name=="_r.2.N1"))
		Nr2Width=N)
		when(((INST->cellName=="stack.PMOS_CHAIN_2.0-L1-R") && (INST->name=="_r.3.P1"))
		Pr3Width=P)
		when(((INST->cellName=="stack.PMOS_CHAIN_1.0-L1-R") && (INST->name=="rv.P10"))
		PrvWidth=P)
		))
		)))
; Calculates the XY origina and bBox to move instances w.r.t the new spec
	foreach(INST CellView->instances
		(let (cordNx cordNx1 cordNx2 cordPx cordPx1 cordPx2 xy1 xy2 XY bx1 bx2 by1 by2 diff)
		xy1=car(INST~>xy)
		xy2=cadr(INST~>xy)
		bx1=caar(INST~>bBox)
		by1=cadar(INST~>bBox)
		bx2=caadr(INST~>bBox)
		by2=cadadr(INST~>bBox)
		when(((INST->cellName=="stack.NMOS_CHAIN_2.0-L1-R") && (INST->name=="_r.2.N1"))
			cordNx=caar(INST~>bBox)
			cordNx1=cordNx+0.02
			cordnx1=cordNx1
			cordNx2=cordNx1-0.06
			cordnx2=cordNx2)
		when(((INST->cellName=="stack.NMOS_CHAIN_2.0-L1-R") && (INST->name=="_r.3.N1"))
			cordNx=caadr(INST~>bBox)
			cordNx1=cordNx-0.02
			cordnr3x1=cordNx1
			cordNx2=cordNx1+0.06
			cordnr3x2=cordNx2)
		when(((INST->cellName=="stack.PMOS_CHAIN_2.0-L1-R") && (INST->name=="_r.3.P1"))
			cordleftr3Px=caar(INST~>bBox)
			cordrightr3Px=caadr(INST~>bBox))
		when(((INST->cellName=="stack.PMOS_CHAIN_2.0-L1-R") && (INST->name=="_r.2.P1"))
			cordPx=caadr(INST~>bBox)
			Lpinx=caar(INST~>bBox)
			cordPx1=cordPx-0.02
			cordpx1=cordPx1
			cordPx2=cordPx1+0.06
			cordpx2=cordPx2)
		when(((INST->cellName=="gate.INV.0-L1_1-R") && (INST->name=="R.0"))
			cordR0y1=cadar(INST~>bBox)
			cordR0y2=cadadr(INST~>bBox))
		when(((INST->cellName=="gate.INV.0-L1_1-R") && (INST->name=="R.2"))
			cordR2x1=caar(INST~>bBox)
			cordR2x2=caadr(INST~>bBox)
			cordR2y2=cadadr(INST~>bBox))
		when(((INST->cellName=="gate.INV.0-L1_1-R") && (INST->name=="R.1"))
			cordR1x1=caar(INST~>bBox)
			cordR1x2=caadr(INST~>bBox)
			cordR1y1=cadar(INST~>bBox)
			cordR1y2=cadadr(INST~>bBox))
		when(((INST->cellName=="gate.INV.0-L1_1-R") && (INST->name=="R.3"))
			cordR3y2=cadadr(INST~>bBox)
			cordleftR3Px=caar(INST~>bBox))
		when(((INST->cellName=="gate.INV.0-L1_1-R") && (INST->name=="Reset"))
		when(ResPWidth>=0.15
			p_contt=0.05
			dbReplaceProp(INST "p_contact_offset" "float" p_contt)
			cordResx2=caadr(INST~>bBox))
		when(ResPWidth<0.15
			p_contt=0.14
			dbReplaceProp(INST "p_contact_offset" "float" p_contt)
			cordResx2=caadr(INST~>bBox)))
		when(((INST->cellName=="gate.INV.0-L1_1-R") && (INST->name=="_Reset"))
			cordresx1=caar(INST~>bBox))
		when(((INST->cellName=="gate.INV.0-L1_1-R") && (INST->name=="L.e"))
			cordLex1=caar(INST~>bBox)
			cordLex2=caadr(INST~>bBox)
			cordLey2=cadadr(INST~>bBox))
		))

	foreach(INST CellView->instances
		(let (xy1 xy2 XY bx1 bx2 by1 by2 diff a1 b1)
		xy1=car(INST~>xy)
		xy2=cadr(INST~>xy)
		bx1=caar(INST~>bBox)
		by1=cadar(INST~>bBox)
		bx2=caadr(INST~>bBox)
		by2=cadadr(INST~>bBox)
		a=float(round((cordleftr3Px-cordR2x2-0.08-0.08+0.000000)*100))/100
		b=float(round((cordleftR3Px-(cordpx1+0.02+0.08+0.08))*100))/100
			when((INST->cellName=="gate.INV.0-L1_1-R") && ((INST->name=="R.3")||(INST->name=="R.1"))&&(a>=b)
			XY=((xy1-b):xy2)
			dbSet(INST XY "xy")
			cordR3NPx2=caadr(INST~>bBox)
			ixy1=car(INST~>xy)
			ixy2=cadr(INST~>xy))
			when((INST->cellName=="gate.INV.0-L1_1-R") && ((INST->name=="R.3")||(INST->name=="R.1"))&&(a<b)
			XY=((xy1-a):xy2)
			dbSet(INST XY "xy")
			cordR3NPx2=caadr(INST~>bBox)
			ixy1=car(INST~>xy)
			ixy2=cadr(INST~>xy))
			when(((INST->cellName=="stack.PMOS_CHAIN_1.0-L1-R")||(INST->cellName=="stack.PMOS_CHAIN_2.0-L1-R")) && ((INST->name=="RP.3")||(INST->name=="RP.1")||(INST->name=="_r.3.P2")||(INST->name=="_r.1.P1")||(INST->name=="_r.3.P1")||(INST->name=="_r.1.P2"))&&(a>=b)
			XY=((xy1-b):xy2)
			dbSet(INST XY "xy")
			cordr3PPx1=caar(INST~>bBox)
			cordr3PPx2=caadr(INST~>bBox))
			when(((INST->cellName=="stack.PMOS_CHAIN_1.0-L1-R")||(INST->cellName=="stack.PMOS_CHAIN_2.0-L1-R")) && ((INST->name=="RP.3")||(INST->name=="RP.1")||(INST->name=="_r.3.P2")||(INST->name=="_r.1.P1")||(INST->name=="_r.3.P1")||(INST->name=="_r.1.P2"))&&(a<b)
			XY=((xy1-a):xy2)
			dbSet(INST XY "xy")
			cordr3PPx1=caar(INST~>bBox)
			cordr3PPx2=caadr(INST~>bBox))
			when(((INST->cellName=="stack.NMOS_CHAIN_1.0-L1-R")||(INST->cellName=="stack.NMOS_CHAIN_2.0-L1-R")) && ((INST->name=="RN.3")||(INST->name=="RN.1")||(INST->name=="_r.3.N2")||(INST->name=="_r.1.N1")||(INST->name=="_r.3.N1")||(INST->name=="_r.1.N2"))&&(a>=b)
			XY=((xy1-b):xy2)
			dbSet(INST XY "xy")
			cordr3NPx1=caar(INST~>bBox)
			cordr3NPx2=caadr(INST~>bBox))
			when(((INST->cellName=="stack.NMOS_CHAIN_1.0-L1-R")||(INST->cellName=="stack.NMOS_CHAIN_2.0-L1-R")) && ((INST->name=="RN.3")||(INST->name=="RN.1")||(INST->name=="_r.3.N2")||(INST->name=="_r.1.N1")||(INST->name=="_r.3.N1")||(INST->name=="_r.1.N2"))&&(a<b)
			XY=((xy1-a):xy2)
			dbSet(INST XY "xy")
			cordr3NPx1=caar(INST~>bBox)
			cordr3NPx2=caadr(INST~>bBox))
			when((INST->cellName=="stack.PMOS_CHAIN_1.0-L1-R")&&((INST->name=="rv.P1")||(INST->name=="rv.P2")||(INST->name=="rv.P3")||(INST->name=="rv.P4")||(INST->name=="rv.P5")||(INST->name=="rv.P6")||(INST->name=="rv.P7")||(INST->name=="rv.P8")||(INST->name=="rv.P9")||(INST->name=="rv.P10"))&&(a>=b)
			XY=((xy1-b):xy2)
			dbSet(INST XY "xy")
			cordrvPPx1=caar(INST~>bBox)
			cordrvPPx2=caadr(INST~>bBox))
			when((INST->cellName=="stack.PMOS_CHAIN_1.0-L1-R")&&((INST->name=="rv.P1")||(INST->name=="rv.P2")||(INST->name=="rv.P3")||(INST->name=="rv.P4")||(INST->name=="rv.P5")||(INST->name=="rv.P6")||(INST->name=="rv.P7")||(INST->name=="rv.P8")||(INST->name=="rv.P9")||(INST->name=="rv.P10"))&&(a<b)
			XY=((xy1-a):xy2)
			dbSet(INST XY "xy")
			cordrvPPx1=caar(INST~>bBox)
			cordrvPPx2=caadr(INST~>bBox))
			when((INST->cellName=="stack.NMOS_CHAIN_5.0-L1-R")&&((INST->name=="rv.N2")||(INST->name=="rv.N1"))&&(a>=b)
			XY=((xy1-b):xy2)
			dbSet(INST XY "xy")
			cordrvNPx1=caar(INST~>bBox)
			cordrvNPx2=caadr(INST~>bBox))
			when((INST->cellName=="stack.NMOS_CHAIN_5.0-L1-R")&&((INST->name=="rv.N2")||(INST->name=="rv.N1"))&&(a<b)
			XY=((xy1-a):xy2)
			dbSet(INST XY "xy")
			cordrvNPx1=caar(INST~>bBox)
			cordrvNPx2=caadr(INST~>bBox))
			when((INST->cellName=="stack.PPLUG.0")
			when(cordR2x2>1.705
			XY=((cordR2x2+0.16):xy2))
			when(cordR2x2<1.705
			XY=(1.9:xy2))
			dbSet(INST XY "xy"))

		))

	foreach(INST CellView->instances
		(let (xy1 xy2 XY bx1 bx2 by1 by2 diff)
		xy1=car(INST~>xy)
		xy2=cadr(INST~>xy)
		bx1=caar(INST~>bBox)
		by1=cadar(INST~>bBox)
		bx2=caadr(INST~>bBox)
		by2=cadadr(INST~>bBox)
		when((INST~>cellName=="M2_M1_2cut_p1_2")&&(xy1==3.125)
		XY=(ixy1-0.195:xy2)
		dbSet(INST XY "xy"))
		when((INST~>cellName=="M2_M1_2cut_p1_2")&&(xy1==3.515)
		XY=(ixy1+0.195:xy2)
		dbSet(INST XY "xy"))
		when((INST->cellName=="gate.INV.0-L1_1-R") && ((INST->name=="R.2")||(INST->name=="R.0"))
		when((cordR2y2==5.16)&&((NWidth/8)<=0.21)
		n_contt=(0.47-0.11-0.09-(NWidth/8))
		dbReplaceProp(INST "n_contact_offset" "float" n_contt)
		cordR2x3=caadr(INST~>bBox)
		cordR2x4=caar(INST~>bBox))
		when((cordR2y2==5.03)&&((NWidth/7)<=0.21)
		n_contt=(0.47-0.11-0.09-(NWidth/7))
		dbReplaceProp(INST "n_contact_offset" "float" n_contt)
		cordR2x3=caadr(INST~>bBox)
		cordR2x4=caar(INST~>bBox))
		when((cordR2y2==4.9)&&((NWidth/6)<=0.21)
		n_contt=(0.47-0.11-0.09-(NWidth/6))
		dbReplaceProp(INST "n_contact_offset" "float" n_contt)
		cordR2x3=caadr(INST~>bBox)
		cordR2x4=caar(INST~>bBox))
		when((cordR2y2==4.77)&&((NWidth/5)<=0.21)
		n_contt=(0.47-0.11-0.09-(NWidth/5))
		dbReplaceProp(INST "n_contact_offset" "float" n_contt)
		cordR2x3=caadr(INST~>bBox)
		cordR2x4=caar(INST~>bBox))
		when((cordR2y2==4.64)&&((NWidth/4)<=0.21)
		n_contt=(0.47-0.11-0.09-(NWidth/4))
		dbReplaceProp(INST "n_contact_offset" "float" n_contt)
		cordR2x3=caadr(INST~>bBox)
		cordR2x4=caar(INST~>bBox))
		when((cordR2y2==4.51)&&((NWidth/3)<=0.21)
		n_contt=(0.47-0.11-0.09-(NWidth/3))
		dbReplaceProp(INST "n_contact_offset" "float" n_contt)
		cordR2x3=caadr(INST~>bBox)
		cordR2x4=caar(INST~>bBox))
		when((cordR2y2==4.38)&&((NWidth/2)<=0.21)
		n_contt=(0.47-0.11-0.09-(NWidth/2))
		dbReplaceProp(INST "n_contact_offset" "float" n_contt)
		cordR2x3=caadr(INST~>bBox)
		cordR2x4=caar(INST~>bBox))
		when((cordR2y2==4.25)&&(NWidth<=0.21)
		n_contt=(0.47-0.11-0.09-NWidth)
		dbReplaceProp(INST "n_contact_offset" "float" n_contt)
		cordR2x3=caadr(INST~>bBox)
		cordR2x4=caar(INST~>bBox))
		when((cordR2y2==5.16)&&((NWidth/8)>0.21)
		n_contt=0.05
		dbReplaceProp(INST "n_contact_offset" "float" n_contt)
		cordR2x3=caadr(INST~>bBox)
		cordR2x4=caar(INST~>bBox))
		when((cordR2y2==5.03)&&((NWidth/7)>0.21)
		n_contt=0.05
		dbReplaceProp(INST "n_contact_offset" "float" n_contt)
		cordR2x3=caadr(INST~>bBox)
		cordR2x4=caar(INST~>bBox))
		when((cordR2y2==4.9)&&((NWidth/6)>0.21)
		n_contt=0.05
		dbReplaceProp(INST "n_contact_offset" "float" n_contt)
		cordR2x3=caadr(INST~>bBox)
		cordR2x4=caar(INST~>bBox))
		when((cordR2y2==4.77)&&((NWidth/5)>0.21)
		n_contt=0.05
		dbReplaceProp(INST "n_contact_offset" "float" n_contt)
		cordR2x3=caadr(INST~>bBox)
		cordR2x4=caar(INST~>bBox))
		when((cordR2y2==4.64)&&((NWidth/4)>0.21)
		n_contt=0.05
		dbReplaceProp(INST "n_contact_offset" "float" n_contt)
		cordR2x3=caadr(INST~>bBox)
		cordR2x4=caar(INST~>bBox))
		when((cordR2y2==4.51)&&((NWidth/3)>0.21)
		n_contt=0.05
		dbReplaceProp(INST "n_contact_offset" "float" n_contt)
		cordR2x3=caadr(INST~>bBox)
		cordR2x4=caar(INST~>bBox))
		when((cordR2y2==4.38)&&((NWidth/2)>0.21)
		n_contt=0.05
		dbReplaceProp(INST "n_contact_offset" "float" n_contt)
		cordR2x3=caadr(INST~>bBox)
		cordR2x4=caar(INST~>bBox))
		when((cordR2y2==4.25)&&(NWidth>0.21)
		n_contt=0.05
		dbReplaceProp(INST "n_contact_offset" "float" n_contt)
		cordR2x3=caadr(INST~>bBox)
		cordR2x4=caar(INST~>bBox)))

		when((INST->cellName=="gate.INV.0-L1_1-R") && ((INST->name=="R.3")||(INST->name=="R.1"))
		when((cordR1y1==1.08)&&((NR1Width/8)<=0.21)
		n_contt=(0.47-0.11-0.09-(NR1Width/8))
		dbReplaceProp(INST "n_contact_offset" "float" n_contt)
		cordR1x3=caadr(INST~>bBox)
		cordR1x4=caar(INST~>bBox))
		when((cordR1y1==1.21)&&((NR1Width/7)<=0.21)
		n_contt=(0.47-0.11-0.09-(NR1Width/7))
		dbReplaceProp(INST "n_contact_offset" "float" n_contt)
		cordR1x3=caadr(INST~>bBox)
		cordR1x4=caar(INST~>bBox))
		when((cordR1y1==1.34)&&((NR1Width/6)<=0.21)
		n_contt=(0.47-0.11-0.09-(NR1Width/6))
		dbReplaceProp(INST "n_contact_offset" "float" n_contt)
		cordR1x3=caadr(INST~>bBox)
		cordR1x4=caar(INST~>bBox))
		when((cordR1y1==1.47)&&((NR1Width/5)<=0.21)
		n_contt=(0.47-0.11-0.09-(NR1Width/5))
		dbReplaceProp(INST "n_contact_offset" "float" n_contt)
		cordR1x3=caadr(INST~>bBox)
		cordR1x4=caar(INST~>bBox))
		when((cordR1y1==1.6)&&((NR1Width/4)<=0.21)
		n_contt=(0.47-0.11-0.09-(NR1Width/4))
		dbReplaceProp(INST "n_contact_offset" "float" n_contt)
		cordR1x3=caadr(INST~>bBox)
		cordR1x4=caar(INST~>bBox))
		when((cordR1y1==1.73)&&((NR1Width/3)<=0.21)
		n_contt=(0.47-0.11-0.09-(NR1Width/3))
		dbReplaceProp(INST "n_contact_offset" "float" n_contt)
		cordR1x3=caadr(INST~>bBox)
		cordR1x4=caar(INST~>bBox))
		when((cordR1y1==1.86)&&((NR1Width/2)<=0.21)
		n_contt=(0.47-0.11-0.09-(NR1Width/2))
		dbReplaceProp(INST "n_contact_offset" "float" n_contt)
		cordR1x3=caadr(INST~>bBox)
		cordR1x4=caar(INST~>bBox))
		when((cordR1y1==1.99)&&(NR1Width<=0.21)
		n_contt=(0.47-0.11-0.09-NR1Width)
		dbReplaceProp(INST "n_contact_offset" "float" n_contt)
		cordR1x3=caadr(INST~>bBox)
		cordR1x4=caar(INST~>bBox))
		when((cordR1y1==1.08)&&((NR1Width/8)>0.21)
		n_contt=0.05
		dbReplaceProp(INST "n_contact_offset" "float" n_contt)
		cordR1x3=caadr(INST~>bBox)
		cordR1x4=caar(INST~>bBox))
		when((cordR1y1==1.21)&&((NR1Width/7)>0.21)
		n_contt=0.05
		dbReplaceProp(INST "n_contact_offset" "float" n_contt)
		cordR1x3=caadr(INST~>bBox)
		cordR1x4=caar(INST~>bBox))
		when((cordR1y1==1.34)&&((NR1Width/6)>0.21)
		n_contt=0.05
		dbReplaceProp(INST "n_contact_offset" "float" n_contt)
		cordR1x3=caadr(INST~>bBox)
		cordR1x4=caar(INST~>bBox))
		when((cordR1y1==1.47)&&((NR1Width/5)>0.21)
		n_contt=0.05
		dbReplaceProp(INST "n_contact_offset" "float" n_contt)
		cordR1x3=caadr(INST~>bBox)
		cordR1x4=caar(INST~>bBox))
		when((cordR1y1==1.6)&&((NR1Width/4)>0.21)
		n_contt=0.05
		dbReplaceProp(INST "n_contact_offset" "float" n_contt)
		cordR1x3=caadr(INST~>bBox)
		cordR1x4=caar(INST~>bBox))
		when((cordR1y1==1.73)&&((NR1Width/3)>0.21)
		n_contt=0.05
		dbReplaceProp(INST "n_contact_offset" "float" n_contt)
		cordR1x3=caadr(INST~>bBox)
		cordR1x4=caar(INST~>bBox))
		when((cordR1y1==1.86)&&((NR1Width/2)>0.21)
		n_contt=0.05
		dbReplaceProp(INST "n_contact_offset" "float" n_contt)
		cordR1x3=caadr(INST~>bBox)
		cordR1x4=caar(INST~>bBox))
		when((cordR1y1==1.99)&&(NR1Width>0.21)
		n_contt=0.05
		dbReplaceProp(INST "n_contact_offset" "float" n_contt)
		cordR1x3=caadr(INST~>bBox)
		cordR1x4=caar(INST~>bBox)))
		))

	foreach(INST CellView->instances
		(let (xy1 xy2 XY bx1 bx2 by1 by2 diff)
		xy1=car(INST~>xy)
		xy2=cadr(INST~>xy)
		bx1=caar(INST~>bBox)
		by1=cadar(INST~>bBox)
		bx2=caadr(INST~>bBox)
		by2=cadadr(INST~>bBox)
		when((INST~>cellName=="M1_POLYmin")&&(((xy2==5.785)&&(xy1==0.11))||((xy2==5.525)&&(xy1==0.11))||((xy2==2.015)&&(xy1==0.11))||((xy2==1.755)&&(xy1==0.11))||((xy2==1.495)&&(xy1==0.11)))
		when(((cordnx1+0.06)<cordR2x4)&&(Nr2Width>0.21)
		XY=(cordnx1-0.03:xy2))
		when(((cordnx1+0.06)<cordR2x4)&&(Nr2Width<0.21)
		XY=(0.53:xy2))
		when(((cordnx1+0.06)>=cordR2x4)
		XY=(cordR2x4-0.03:xy2))
		dbSet(INST XY "xy")) ;moves M1_poly vias on the left side of C2 gates in 1st coloumn
		when((INST~>cellName=="M1_POLYmin")&&(((xy2==4.745)&&(xy1==4.28))||((xy2==4.485)&&(xy1==4.28))||((xy2==4.225)&&(xy1==4.28))||((xy2==0.715)&&(xy1==4.28))||((xy2==0.455)&&(xy1==4.28)))
		when(((cordr3NPx2-0.06)>cordR1x3)&&(Nr3Width>0.21)
		XY=(cordr3NPx2+0.01:xy2)
		rightpoly=car(INST~>xy))
		when(((cordr3NPx2-0.06)>cordR1x3)&&(Nr3Width<0.21)
		XY=(3.86:xy2)
		rightpoly=car(INST~>xy))
		when(((cordr3NPx2-0.06)<=cordR1x3)
		XY=(cordR1x3+0.03:xy2)
		rightpoly=car(INST~>xy))
		dbSet(INST XY "xy")) ;moves M1_poly vias on the right side of C2 gates in 2nd coloumn
		when((INST~>cellName=="M1_POLYmin")&&(((xy2==5.915)&&(xy1==2.28))||((xy2==5.655)&&(xy1==2.28))||((xy2==2.145)&&(xy1==2.28))||((xy2==1.885)&&(xy1==2.28)))
		XY=(cordpx1+0.03:xy2)
		dbSet(INST XY "xy")) ;moves M1_poly vias on the right side of C2 gates in 1st coloumn
		when((INST~>cellName=="M1_POLYmin")&&(xy2==5.265)&&(xy1==1.78)
		when(cordR2x2>1.705
		XY=(cordR2x2+0.01:xy2))
		when(cordR2x2<1.705
		XY=(1.725:xy2))
		dbSet(INST XY "xy")) ;moves M1_poly vias on the right side of PMOS chains of C2 gates in 1st coloumn
		when((INST~>cellName=="M1_POLYmin")&&(((xy2==4.355)&&(xy1==1.97))||((xy2==4.095)&&(xy1==1.97))||((xy2==0.975)&&(xy1==1.97))||((xy2==0.585)&&(xy1==1.97))||((xy2==0.325)&&(xy1==1.97)))
		XY=(cordR2x3+0.15:xy2)
		dbSet(INST XY "xy")) ;moves M1_poly vias on the left side of PMOS chains of C2 gates in 1st coloumn
		when((INST->cellName=="stack.NPLUG.0")&&(xy1==0.13)
		when(((cordnx1+0.06)<cordR2x4)&&(Nr2Width>0.21)
		XY=((cordnx1-0.01):xy2))
		when(((cordnx1+0.06)<cordR2x4)&&(Nr2Width<0.21)
		XY=(0.51:xy2))
		when(((cordnx1+0.06)>=cordR2x4)
		XY=((cordR2x4-0.01):xy2))
		leftNPLUG=car(XY)-0.13
		dbSet(INST XY "xy")) ; moves the NPLUG on the left side in the 1st coloumn

		))

	foreach(INST CellView->instances
		(let (xy1 xy2 XY bx1 bx2 by1 by2 diff)
		xy1=car(INST~>xy)
		xy2=cadr(INST~>xy)
		bx1=caar(INST~>bBox)
		by1=cadar(INST~>bBox)
		bx2=caadr(INST~>bBox)
		by2=cadadr(INST~>bBox)
		when((INST->cellName=="stack.NPLUG.0")&&(xy1==4.29)
		when(cordrvNPx2+0.23>=rightpoly+0.07
		XY=((cordrvNPx2+0.14):xy2))
		when(cordrvNPx2+0.23<rightpoly+0.07
		XY=((rightpoly-0.02):xy2))
		rightNPLUG=car(XY)+0.13
		dbSet(INST XY "xy")) ; moves the NPLUG on the right side in the 2nd coloumn

		))

	foreach(SHAPE CellView->shapes
		(let (bx1 bx2 by1 by2 x1 x2 x3 x4 x5 x6 x7 x8 y1 y2 y3 y4 y5 y6 y7 y8 xy1 xy2 pnts bbox orgn)
		bx1=caar(SHAPE~>bBox)
		by1=cadar(SHAPE~>bBox)
		bx2=caadr(SHAPE~>bBox)
		by2=cadadr(SHAPE~>bBox)
		xy1=car(SHAPE~>xy)
		xy2=cadr(SHAPE~>xy)
		x1=caar(SHAPE~>points)
		y1=cadar(SHAPE~>points)
		x2=caadr(SHAPE~>points)
		y2=cadadr(SHAPE~>points)
		x3=caaddr(SHAPE~>points)
		y3=car(cdaddr(SHAPE~>points))
		x4=car(cadddr(SHAPE~>points))
		y4=cadr(cadddr(SHAPE~>points))
		x5=caar(cddddr(SHAPE~>points))
		y5=cadar(cddddr(SHAPE~>points))
		x6=caadr(cddddr(SHAPE~>points))
		y6=cadadr(cddddr(SHAPE~>points))
		x7=caaddr(cddddr(SHAPE~>points))
		y7=car(cdaddr(cddddr(SHAPE~>points)))
		x8=car(cadddr(cddddr(SHAPE~>points)))
		y8=cadr(cadddr(cddddr(SHAPE~>points)))
		when((SHAPE~>layerName=="M2")&&((SHAPE~>net~>name=="_r.2")||(SHAPE~>net~>name=="_r.0"))&&(((bx1==0.21)&&(by1==4.065))||((bx1==0.21)&&(by1==0.295)))
		when(((cordR2x4+0.07)<=0.545)
		pnts=list((cordR2x4+0.07):y1 (cordR2x4+0.07):y2 ))
		when(((cordR2x4+0.07)>0.545)
		pnts=list(0.545:y1 0.545:y2 ))
		dbSet(SHAPE pnts "points")
		Actualr2x=caar(SHAPE~>bBox)) ;Moves M2 wire connecting _r.2/_r.0 to the input of the R.2/R.0 INV
		when((SHAPE~>layerName=="M2")&&((SHAPE~>net~>name=="L.2")||(SHAPE~>net~>name=="L.0"))&&(((bx1==0.08)&&(by1==4.45))||((bx1==0.08)&&(by1==0.285)))
		when(((cordnx1+0.06)<cordR2x4)&&(Nr2Width>0.21)&&((cordR2x4+0.07)>(cordnx1-0.01))
		pnts=list((cordnx1-0.03):y1 (cordnx1-0.03):y2 ))
		when(((cordnx1+0.06)<cordR2x4)&&(Nr2Width>0.21)&&((cordR2x4+0.07)<=(cordnx1-0.01))
		pnts=list(0.415:y1 0.415:y2 ))
		when(((cordnx1+0.06)<cordR2x4)&&(Nr2Width<0.21)
		pnts=list(0.415:y1 0.415:y2 ))
		when(((cordnx1+0.06)>=cordR2x4)&&((cordR2x4+0.07)<=0.545)
		pnts=list((cordR2x4-0.03):y1 (cordR2x4-0.03):y2 ))
		when(((cordnx1+0.06)>=cordR2x4)&&((cordR2x4+0.07)>0.545)
		pnts=list(0.415:y1 0.415:y2 ))
		dbSet(SHAPE pnts "points")
		ActualL2x=caar(SHAPE~>bBox)) ;Moves M2 wire connecting L.2/L.0 to the respective M3 pins
		when((SHAPE~>layerName=="M2")&&((SHAPE~>net~>name=="R.e")||(SHAPE~>net~>name=="L.1"))&&(((bx1==4.25)&&(by1==0.46))||((bx1==4.25)&&(by1==2.925)))
		when(((cordnr3x1-0.06)>cordR1x3)&&(Nr3Width>0.21)
		pnts=list((cordnr3x1+0.03):y1 (cordnr3x1+0.03):y2))
		when(((cordnr3x1-0.06)>cordR1x3)&&(Nr3Width<0.21)
		pnts=list(3.86:y1 3.86:y2))
		when(((cordnr3x1-0.06)<=cordR1x3)
		pnts=list((cordnR1x3+0.03):y1 (cordnR1x3+0.03):y2))
		dbSet(SHAPE pnts "points")) ;Moves M2 wire connecting _r.2/_r.0 to the input of the R.2/R.0 INV
		when((SHAPE~>layerName=="M1")&&(SHAPE~>net~>name=="_r.2")&&((bx1==0.375)&&(by1==3.75))
		pnts=list((cordrvPPx1-0.26):y1 (cordR2x4+0.07):y2 (cordR2x4+0.07):y3)
		dbSet(SHAPE pnts "points")) ;Moves M1 wire connecting _r.2 with the input of the NAND5 gate
		when((SHAPE~>layerName=="M1")&&(SHAPE~>net~>name=="R.0")&&((bx1==0.08)&&(by1==0.1))
		when(((cordnx1+0.06)<cordR2x4)&&(Nr2Width>0.21)
		pnts=list((cordnx1-0.03):y1 (cordnx1-0.03):y2 x3:y3))
		when(((cordnx1+0.06)<cordR2x4)&&(Nr2Width<0.21)
		pnts=list(0.53:y1 0.53:y2 x3:y3))
		when(((cordnx1+0.06)>=cordR2x4)
		pnts=list((cordR2x4-0.03):y1 (cordR2x4-0.03):y2 x3:y3))
		dbSet(SHAPE pnts "points")) ;Moves M1 wire connecting R.0 with the input of the NAND5 gate
		when((SHAPE~>layerName=="M1")&&((SHAPE~>net~>name=="_r.2")||(SHAPE~>net~>name=="_r.0"))&&(((bx1==0.21)&&(by1==4.975))||((bx1==0.21)&&(by1==4.715))||((bx1==0.21)&&(by1==4.455))||((bx1==0.21)&&(by1==4.195))||((bx1==0.21)&&(by1==1.205))||((bx1==0.21)&&(by1==0.945))||((bx1==0.21)&&(by1==0.945))||((bx1==0.21)&&(by1==0.685))||((bx1==0.21)&&(by1==0.425)))
		when(((cordR2x4+0.07)<=0.545)
		bbox=list((cordR2x4+0.07):by1 (cordR2x4+0.04):by2 ))
		when(((cordR2x4+0.07)>0.545)
		bbox=list(0.545:by1 (cordR2x4+0.04):by2 ))
		dbSet(SHAPE bbox "bBox")); moves M1 connecting the _r.2 connecting from the M2 to the Poly_M1 vias of the R.2/R.0 INV gate
		when((SHAPE~>layerName=="M1")&&((SHAPE~>net~>name=="L.2")||(SHAPE~>net~>name=="L.0"))&&(((by1==5.465)&&(by2==5.845))||((by1==1.695)&&(by2==2.075)))
		when(((cordnx1+0.06)<cordR2x4)&&(Nr2Width>0.21)
		bbox=list((cordnx1-0.06):by1 cordnx1:by2 ))
		when(((cordnx1+0.06)<cordR2x4)&&(Nr2Width<0.21)
		bbox=list(0.5:by1 0.56:by2 ))
		when(((cordnx1+0.06)>=cordR2x4)
		bbox=list((cordR2x4-0.06):by1 cordR2x4:by2 ))
		dbSet(SHAPE bbox "bBox")); moves M1 connecting the _r.2 connecting from the M2 to the Poly_M1 vias of the R.2/R.0 INV gate
		when((SHAPE~>layerName=="M1")&&(((by1==5.595)&&(by2==5.975))||((by1==1.805)&&(by2==2.225)))
		bbox=list(cordpx1:by1 (cordpx1+0.06):by2 )
		dbSet(SHAPE bbox "bBox")); moves M1 connecting the _r.2 connecting from the M2 to the Poly_M1 vias of the R.2/R.0 INV gate
		when((SHAPE~>layerName=="PO")&&(((by1==5.45)&&(by2==5.99))||((by1==1.68)&&(by2==2.22))||((by1==1.42)&&(by2==1.57))||((by1==5.19)&&(by2==5.34))||((by1==4.67)&&(by2==4.82)))
		bbox=list((cordpx1+0.1):by1 (cordpx1+0.18):by2 )
		dbSet(SHAPE bbox "bBox")); moves Cut_Poly after the C2 gates in the 1st coloumn
		when((SHAPE~>layerName=="PO")&&(((by1==4.02)&&(by2==4.56))||((by1==0.25)&&(by2==0.79))||((by1==1.16)&&(by2==1.31))||((by1==0.9)&&(by2==1.05)))
		bbox=list(cordR2x3:by1 (cordR2x3+0.08):by2 )
		dbSet(SHAPE bbox "bBox")); moves Cut_Poly after the C2 gates in the 1st coloumn
		when((SHAPE~>layerName=="PO")&&(((by1==2.72)&&(by2==3.65))||((by1==2.46)&&(by2==2.61)))
		bbox=list(cordLex2:by1 (cordLex2+0.08):by2 )
		dbSet(SHAPE bbox "bBox")); moves Cut_Poly after the L.e/Reset gates in the 1st coloumn
		when((SHAPE~>layerName=="M1")&&(SHAPE~>net~>name=="Reset")&&(by1==2.375)&&(bx1==0.53)
		pnts=list(x1:y1 (cordresx1+0.08):y2 (cordresx1+0.08):y3)
		dbSet(SHAPE pnts "points")); moves M1 connecting the Reset to the Poly_M1 vias of the _Reset INV gate
		when((SHAPE~>layerName=="M2")&&(SHAPE~>net~>name=="_RESET")
		pnts=list((cordResx2-0.08):y1 (cordResx2-0.08):y2)
		dbSet(SHAPE pnts "points")); moves M2 connecting the _RESET to the Poly_M1 vias of the Reset INV gate
		when((SHAPE~>layerName=="M1")&&(SHAPE~>net~>name=="_RESET")
		bbox=list(cordResx2-0.11:by1 cordResx2-0.015:by2)
		dbSet(SHAPE bbox "bBox")); moves M1 connecting the Reset to the Poly_M1 vias of the _Reset INV gate
		when((SHAPE~>layerName=="M1")&&(by1==4.91)&&(bx1==1.59)
		when(cordR2x2>1.705
		pnts=list(1.06:y1 (cordR2x2+0.01):y2 (cordR2x2+0.01):y3))
		when(cordR2x2<1.705
		pnts=list(1.06:y1 1.725:y2 1.725:y3))
		dbSet(SHAPE pnts "points")); moves M1 connecting the R.2 ouput of the INV gate to the internal connection of the C2 gates i.e nmos/pmos chains
		when((SHAPE~>layerName=="PO")&&(by1==5.25)&&(bx1==0.79)
		when(cordR2x2>1.705
		bbox=list(bx1:by1 (cordR2x2+0.01):by2))
		when(cordR2x2<1.705
		bbox=list(bx1:by1 1.725:by2))
		dbSet(SHAPE bbox "bBox")); Moves the Poly connecting the M1_Poly vias of the nmos.pmos chains of C2 gates in the 1st coloumn
		when((SHAPE~>layerName=="PO")&&(((bx1==1.97)&&(by1==4.34))||((bx1==1.97)&&(by1==0.96))||((bx1==1.97)&&(by1==4.08))||((bx1==1.97)&&(by1==0.57))||((bx1==1.97)&&(by1==0.31)))
		bbox=list(cordR2x3+0.15:by1 ixy1+0.2:by2 )
		dbSet(SHAPE bbox "bBox")); moves Poly connecting the Poly_M1 vias connecting the L.3/R.e inputs in the 2nd coloumn
		when((SHAPE~>layerName=="NP")&&(by1==4.695)&&(bx1==2.165)
		when(cordR2x2>1.705
		bbox=list((cordR2x2+0.16):by1 (cordR2x2+0.33):by2))
		when(cordR2x2<1.705
		bbox=list(1.875:by1 2.045:by2))
		dbSet(SHAPE bbox "bBox")); moves NP layer over the PPLUG according to the PPLUG
		when((SHAPE~>layerName=="M2")&&(SHAPE~>net~>name=="rv")&&(bx1==1.625)&&(by1==2.79)
		pnts=list((cordLex2-0.055):y1 (cordLex2-0.055):y2)
		dbSet(SHAPE pnts "points")); moves M2 connecting the rv input of the L.e INV gate with the internal connections of the NAND5 gate.
		when((SHAPE~>layerName=="M2")&&(SHAPE~>net~>name=="Vdd")&&(bx1==3.045)&&(by1==0.19)
		bbox=list((ixy1-0.275):by1 (ixy1-0.115):by2)
		dbSet(SHAPE bbox "bBox")); moves M2 Vdd power strip in the 2nd coloumn
		when((SHAPE~>layerName=="M2")&&(bx1==3.435)&&(by1==0.07)
		bbox=list((ixy1+0.115):by1 (ixy1+0.275):by2)
		dbSet(SHAPE bbox "bBox")); moves M2 GND power strip in the 2nd coloumn
		when((SHAPE~>layerName=="M2")&&(((bx1==3.29)&&(by1==4.95))||((bx1==3.29)&&(by1==4.135))||((bx1==3.29)&&(by1==2.54))||((bx1==3.29)&&(by1==1.275))||((bx1==3.29)&&(by1==0.335)))
		pnts=list(ixy1:y1 ixy1:y2)
		dbSet(SHAPE pnts "points")); moves M2 connecting different nets in the centre of the 2nd coloumn i.e in betweeen Vdd and GND
		when((SHAPE~>layerName=="CO")&&((bx1==4&&by1==2.775)||(bx1==4&&by1==3.425))
		bbox=list((cordrvNPx2+0.01):by1 (cordrvNPx2+0.05):by2)
		dbSet(SHAPE bbox "bBox")) ; moves the CO's connecting the _r.1 inputs of the NAND5 gate
		when((SHAPE~>layerName=="PO")&&((bx1==3.13&&by1==3.43)||(bx1==3.13&&by1==2.78))
		bbox=list((ixy1-0.05):by1 (cordrvNPx2+0.1):by2)
		dbSet(SHAPE bbox "bBox")) ; moves the PO connecting the _r.1 inputs of the NAND5 gate
		when((SHAPE~>layerName=="M1")&&by1==2.71&&by2==3.525
		bbox=list(cordrvNPx2:by1 (cordrvNPx2+0.06):by2)
		dbSet(SHAPE bbox "bBox")) ; moves the M1 connecting the _r.1 inputs of the NAND5 gate
		when((SHAPE~>layerName=="CO")&&((bx1==4.13&&by1==3.035)||(bx1==4.13&&by1==3.685))
		bbox=list((cordrvNPx2+0.14):by1 (cordrvNPx2+0.18):by2)
		dbSet(SHAPE bbox "bBox")) ; moves the CO's connecting the _r.3 inputs of the NAND5 gate
		when((SHAPE~>layerName=="PO")&&((bx1==3.13&&by1==3.04)||(bx1==3.13&&by1==3.69))
		bbox=list((ixy1-0.05):by1 (cordrvNPx2+0.23):by2)
		dbSet(SHAPE bbox "bBox")) ; moves the PO's connecting the _r.3 inputs of the NAND5 gate
		when((SHAPE~>layerName=="M1")&&bx1==4.085&&by1==3.705
		pnts=list((cordrvNPx2+0.16):y1 (cordrvNPx2+0.16):y2 Actualr1x:y3)
		dbSet(SHAPE pnts "points")) ; Moves M1 connecting the _r.3 input of NAND5 with the M2 wire
		when((SHAPE~>layerName=="M1")&&by1==2.97&&by2==3.795
		bbox=list((cordrvNPx2+0.13):by1 (cordrvNPx2+0.19):by2)
		dbSet(SHAPE bbox "bBox")) ; moves the M1's connecting the _r.3 inputs of the NAND5 gate
		when((SHAPE~>layerName=="CO")&&((bx1==2.91&&by1==2.515)||(bx1==2.91&&by1==3.165))
		bbox=list((cordrvPPx1-0.01):by1 (cordrvPPx1-0.05):by2)
		dbSet(SHAPE bbox "bBox")) ; moves the CO's connecting the _Reset inputs of the NAND5 gate
		when((SHAPE~>layerName=="PO")&&((bx1==2.85&&by1==2.52)||(bx1==2.85&&by1==3.17))
		bbox=list((ixy1+0.05):by1 (cordrvPPx1-0.1):by2)
		dbSet(SHAPE bbox "bBox")) ; moves the PO's connecting the _Reset inputs of the NAND5 gate
		when((SHAPE~>layerName=="M1")&&by1==2.475&&by2==3.275
		bbox=list(cordrvPPx1:by1 (cordrvPPx1-0.06):by2)
		dbSet(SHAPE bbox "bBox")) ; moves the M1 connecting the _Reset inputs of the NAND5 gate
		when((SHAPE~>layerName=="CO")&&((bx1==2.78&&by1==2.645)||(bx1==2.78&&by1==3.295))
		bbox=list((cordrvPPx1-0.14):by1 (cordrvPPx1-0.18):by2)
		dbSet(SHAPE bbox "bBox")) ; moves the CO's connecting the _r.0 inputs of the NAND5 gate
		when((SHAPE~>layerName=="PO")&&((bx1==2.72&&by1==2.65)||(bx1==2.72&&by1==3.3))
		bbox=list((ixy1+0.05):by1 (cordrvPPx1-0.23):by2)
		dbSet(SHAPE bbox "bBox")) ; moves the PO's connecting the _r.0 inputs of the NAND5 gate
		when((SHAPE~>layerName=="M1")&&bx1==2.77&&by1==2.64
		bbox=list((cordrvPPx1-0.13):by1 (cordrvPPx1-0.19):by2)
		dbSet(SHAPE bbox "bBox")) ; moves the M1 connecting the _r.0 inputs of the NAND5 gate
		when((SHAPE~>layerName=="CO")&&((bx1==2.65&&by1==3.555)||(bx1==2.65&&by1==2.905))
		bbox=list((cordrvPPx1-0.27):by1 (cordrvPPx1-0.31):by2)
		dbSet(SHAPE bbox "bBox")) ; moves the CO's connecting the _r.2 inputs of the NAND5 gate
		when((SHAPE~>layerName=="PO")&&((bx1==2.59&&by1==2.91)||(bx1==2.59&&by1==3.56))
		bbox=list((ixy1+0.05):by1 (cordrvPPx1-0.36):by2)
		dbSet(SHAPE bbox "bBox")) ; moves the PO's connecting the _r.2 inputs of the NAND5 gate
		when((SHAPE~>layerName=="M1")&&by1==2.865&&by2==3.81
		bbox=list((cordrvPPx1-0.26):by1 (cordrvPPx1-0.32):by2)
		dbSet(SHAPE bbox "bBox")) ; moves the M1 connecting the _r.2 inputs of the NAND5 gate
		when((SHAPE~>layerName=="M1")&&(SHAPE~>net~>name=="rv")&&bx1==2.9&&by1==3.35
		pnts=list((ixy1-0.09):y1 (cordrvPPx1-0.06):y2 (cordrvPPx1-0.06):y3 (ixy1-0.09):y4 (ixy1-0.09):y5 cordrvPPx1:y6 cordrvPPx1:y7 (ixy1-0.09):y8)
		dbSet(SHAPE pnts "points")) ; moves the M1 connecting the rv inputs internally of the NAND5 gate
		when((SHAPE~>layerName=="M1")&&((bx1==3.19&&by1==2.57)||(bx1==3.19&&by1==2.83)||(bx1==3.19&&by1==3.35))
		bbox=list(ixy1:by1 (ixy1-0.15):by2)
		dbSet(SHAPE bbox "bBox")) ; moves the M1 connecting internally the rv inputs of the NAND5 gate
		when((SHAPE~>layerName=="M1")&&(SHAPE~>net~>name=="_Reset")&&bx1==1.075&&by1==2.31
		pnts=list(x1:y1 (ixy1-0.53):y2 (ixy1-0.53):y3 (cordrvPPx1-0.06):y4)
		dbSet(SHAPE pnts "points")) ; moves the M1 _Reset connecting to the _Reset INV gate
		when((SHAPE~>layerName=="M1")&&(SHAPE~>net~>name=="_r.0")&&bx1==1.705&&by1==2.55
		pnts=list(x1:y1 (ixy1-0.65):y2 (ixy1-0.65):y3 (cordrvPPx1-0.19):y4)
		dbSet(SHAPE pnts "points")) ; moves the M1 _r.0 connecting to the _r.0 output of the respective C2 gate
		when((SHAPE~>layerName=="M2")&&(SHAPE~>net~>name=="L.3")&&bx1==1.94&&by1==4.065
		pnts=list(cordR2x3+0.15:y1 cordR2x3+0.15:y2)
		dbSet(SHAPE pnts "points")) ; moves the M2 of L.3 connecting to the M3 pin of L.3
		when((SHAPE~>layerName=="M1")&&(SHAPE~>net~>name=="L.3")&&by1==4.065&&by2==4.385
		bbox=list(cordR2x3+0.12:by1 cordR2x3+0.18:by2)
		dbSet(SHAPE bbox "bBox")) ; moves the M1 of L.3 connecting to the M3 pin of L.3
		when((SHAPE~>layerName=="M2")&&bx1==2.07&&by1==0.085
		when((cordR2x3+0.28>=cordLex2-0.055)
		pnts=list(cordR2x3+0.28:y1 cordR2x3+0.28:y2))
		when((cordR2x3+0.28<cordLex2-0.055)
		pnts=list(cordLex2+0.075:y1 cordLex2+0.075:y2))
		dbSet(SHAPE pnts "points")) ; moves the M2 of R.e connecting to the M3 pin of R.e
		when((SHAPE~>layerName=="M1")&&((bx1==2.09&&by1==5.855)||(bx1==2.09&&by1==1.53))
		when((cordR2x3+0.28>=cordLex2-0.055)
		pnts=list(cordR2x3+0.28:y1 cordpx1+0.03:y2 cordpx1+0.03:y3))
		when((cordR2x3+0.28<cordLex2-0.055)
		pnts=list(cordLex2+0.075:y1 cordpx1+0.03:y2 cordpx1+0.03:y3))
		dbSet(SHAPE pnts "points")) ; moves the M1 of R.e connecting to the M3 pin of R.e
		when((SHAPE~>layerName=="M1")&&bx1==1.94&&by1==0.1
		when((cordR2x3+0.28>=cordLex2-0.055)
		pnts=list(cordR2x3+0.28:y1 cordR2x3+0.15:y2 cordR2x3+0.15:y3))
		when((cordR2x3+0.28<cordLex2-0.055)
		pnts=list(cordLex2+0.075:y1 cordR2x3+0.15:y2 cordR2x3+0.15:y3))
		dbSet(SHAPE pnts "points")) ; moves the M1 of R.e connecting to the M3 pin of R.e
		when((SHAPE~>layerName=="M1")&&by1==0.295&&by2==0.615
		bbox=list(cordR2x3+0.12:by1 cordR2x3+0.18:by2)
		dbSet(SHAPE bbox "bBox")) ; moves the M1 of R.e connecting to the M3 pin of R.e
		when((SHAPE~>layerName=="M1")&&bx1==1.95&&by1==0.945
		pnts=list(ixy1:y1 cordR2x3+0.15:y2 cordR2x3+0.15:y3)
		dbSet(SHAPE pnts "points")) ; moves the M1 of R.e connecting to the M3 pin of R.e
		when((SHAPE~>layerName=="M1")&&bx1==2.16&&by1==5.045
		when(cordR2x2>1.705
		pnts=list(ixy1-0.09:y1 cordR2x2+0.16:y2 cordR2x2+0.16:y3))
		when(cordR2x2<1.705
		pnts=list(ixy1-0.09:y1 1.9:y2 1.9:y3))
		dbSet(SHAPE pnts "points")) ; moves the M1 connecting the PPLUG to the Vdd
		when((SHAPE~>layerName=="M2")&&bx1==2.905&&by1==1.88
		pnts=list(ixy1-0.385:y1 ixy1-0.385:y2)
		dbSet(SHAPE pnts "points")) ; moves the M2 connecting to the M3 pin of L.1
		when((SHAPE~>layerName=="M2")&&((by1==4.12&&bx1==2.905)||(by1==0.35&&bx1==2.905))
		bbox=list(ixy1-0.415:by1 ixy1-0.355:by2)
		dbSet(SHAPE bbox "bBox")) ; moves the M2 connecting to the internal nets on the left side of the C2 gates to the PMOS/NMOs chains
		when((SHAPE~>layerName=="M2")&&((by1==4.38&&bx1==2.785)||(by1==0.61&&bx1==2.785))
		bbox=list(ixy1-0.475:by1 ixy1-0.535:by2)
		dbSet(SHAPE bbox "bBox")) ; moves the M2 connecting to the internal nets on the left side of the C2 gates to the PMOS/NMOs chains
		when((SHAPE~>layerName=="M2")&&((by1==4.38&&bx1==3.675)||(by1==0.61&&bx1==3.675))
		bbox=list(ixy1+0.355:by1 ixy1+0.415:by2)
		dbSet(SHAPE bbox "bBox")) ; moves the M2 connecting to the internal nets on the right side of the C2 gates to the PMOS/NMOs chains
		when((SHAPE~>layerName=="M1")&&bx1==3.06&&by1==3.09
		bbox=list(ixy1-0.15:by1 ixy1+0.15:by2)
		dbSet(SHAPE bbox "bBox")) ; moves the M1 connecting the rv input in the centre of the NAND5 gate
		when((SHAPE~>layerName=="M1")&&((bx1==2.23&&by1==0.36)||(bx1==2.19&&by1==0.62)||(bx1==2.23&&by1==4.13)||(bx1==2.19&&by1==4.39))
		bbox=list(ixy1-0.09:by1 cordr3PPx1+0.09:by2)
		dbSet(SHAPE bbox "bBox")) ; moves the M1 over the CO's on the C2 gates in the 2nd coloumn on the left side i.e PMOS
		when((SHAPE~>layerName=="M1")&&((bx1==3.29&&by1==0.36)||(bx1==3.29&&by1==4.13))
		bbox=list(ixy1-0.03:by1 cordr3NPx2-0.09:by2)
		dbSet(SHAPE bbox "bBox")) ; moves the M1 over the CO's on the C2 gates in the 2nd coloumn on the right side i.e NMOS in the lower half
		when((SHAPE~>layerName=="M1")&&((bx1==3.41&&by1==0.62)||(bx1==3.41&&by1==4.39))
		bbox=list(ixy1+0.09:by1 cordr3NPx2-0.09:by2)
		dbSet(SHAPE bbox "bBox")) ; moves the M1 over the CO's on the C2 gates in the 2nd coloumn on the right side i.e NMOS in the upper half
		when((SHAPE~>layerName=="M1")&&((bx1==1.15&&by1==5.82)||(bx1==1.15&&by1==5.56)||(bx1==1.15&&by1==2.05)||(bx1==1.15&&by1==1.79))
		bbox=list(bx1:by1  cordpx1-0.07:by2)
		dbSet(SHAPE bbox "bBox")) ; moves the M1 over the CO's on the C2 gates in the 1st coloumn on the right side i.e PMOS
		when((SHAPE~>layerName=="M1")&&((bx1==1.15&&by1==5.82)||(bx1==1.15&&by1==5.56)||(bx1==1.15&&by1==2.05)||(bx1==1.15&&by1==1.79))
		i = 1.18
		for(k 0 20
		dbCreateRect(CellView "CO" list(i:(by1+0.01) i+0.04:(by2-0.01)))
		when((i+0.15)>(cordpx1-0.07)
		k=20
		i = 1.18)
		when((i+0.15)<=(cordpx1-0.07)
		k = k+1
		i = i + 0.11))) ; draws CO for the internal nets of the C2 gates on the right side of the C2 gates in the 1st coloumn i.e on the PMOS side
		when((SHAPE~>layerName=="M1")&&((bx1==0.33&&by1==5.82)||(bx1==0.335&&by1==2.05))
		i = 0.94
		for(k 0 20
		dbCreateRect(CellView "CO" list(i:(by1+0.01) i-0.04:(by2-0.01)))
		when((i-0.15)<(cordnx1+0.07)
		k=20
		i = 0.94)
		when((i-0.15)>=(cordnx1+0.07)
		k = k+1
		i = i - 0.11))) ; draws CO  for the internal nets of the C2 gates on the left side of the C2 gates in the 1st coloumn i.e on the NMOS side
		when((SHAPE~>layerName=="M1")&&((bx1==0.32&&by1==5.56)||(bx1==0.32&&by1==1.79))
		i = 0.94
		for(k 0 20
		dbCreateRect(CellView "CO" list(i:(by1+0.01) i-0.04:(by2-0.01)))
		when((i-0.15)<(cordnx1+0.07)
		k=20
		i = 0.94)
		when((i-0.15)>=(cordnx1+0.07)
		k = k+1
		i = i - 0.11))) ; draws CO  for the internal nets of the C2 gates on the left side of the C2 gates in the 1st coloumn i.e on the NMOS side
		when((SHAPE~>layerName=="M1")&&((bx1==2.23&&by1==0.36)||(bx1==2.19&&by1==0.62)||(bx1==2.23&&by1==4.13)||(bx1==2.19&&by1==4.39))
		i = ixy1-0.12
		for(k 0 20
		dbCreateRect(CellView "CO" list(i:(by1+0.01) i-0.04:(by2-0.01)))
		when((i-0.15)<(cordr3PPx1+0.09)
		k=20
		i = ixy1-0.12)
		when((i-0.15)>=(cordr3PPx1+0.09)
		k = k+1
		i = i - 0.11))); draws CO for the internal nets of the C2 gates on the left side of the C2 gates in the 2nd coloumn i.e on the PMOS side
		when((SHAPE~>layerName=="M1")&&((bx1==3.29&&by1==0.36)||(bx1==3.29&&by1==4.13))
		i = ixy1+0.12
		for(k 0 20
		dbCreateRect(CellView "CO" list(i:(by1+0.01) i+0.04:(by2-0.01)))
		when((i+0.15)>(cordr3NPx2-0.09)
		k=20
		i = ixy1+0.12)
		when((i+0.15)<=(cordr3NPx2-0.09)
		k = k+1
		i = i + 0.11))); draws CO for the internal nets of the C2 gates on the right side of the C2 gates in the 2nd coloumn i.e on the NMOS side
		when((SHAPE~>layerName=="M1")&&((bx1==3.41&&by1==0.62)||(bx1==3.41&&by1==4.39))
		i = ixy1+0.12
		for(k 0 20
		dbCreateRect(CellView "CO" list(i:(by1+0.01) i+0.04:(by2-0.01)))
		when((i+0.15)>(cordr3NPx2-0.09)
		k=20
		i = ixy1+0.12)
		when((i+0.15)<=(cordr3NPx2-0.09)
		k = k+1
		i = i + 0.11))); draws CO for the internal nets of the C2 gates on the right side of the C2 gates in the 2nd coloumn i.e on the NMOS side

		when((SHAPE~>layerName=="M1")&&((bx1==0.33&&by1==5.82)||(bx1==0.335&&by1==2.05))
		bbox=list(cordnx1+0.07:by1  bx2:by2)
		dbSet(SHAPE bbox "bBox")) ; moves the M1 over the CO's on the C2 gates in the 1st coloumn on the left side i.e NMOS
		when((SHAPE~>layerName=="M1")&&((bx1==0.32&&by1==5.56)||(bx1==0.32&&by1==1.79))
		bbox=list(cordnx1+0.07:by1  0.97:by2)
		dbSet(SHAPE bbox "bBox")) ; moves the M1 over the CO's on the C2 gates in the 1st coloumn on the left side i.e NMOS
		when((SHAPE~>layerName=="M1")&&((bx1==3.29&&by1==4.65)||(bx1==3.29&&by1==0.88))
		bbox=list(ixy1-0.03:by1  ixy1+0.19:by2)
		dbSet(SHAPE bbox "bBox")) ; moves the M1 connecting the internal nets with the PMOS/NMOS chains of the C2 gate

		when((SHAPE~>layerName=="M1")&&(bx1==2.935&&by1==0.88)||(bx1==2.935&&by1==4.65)
		bbox=list(ixy1-0.09:by1 ixy1-0.415:by2)
		dbSet(SHAPE bbox "bBox")) ; moves the M1 connecting the M2 which is connecting the internal net of R.3 C2 stat on left side
		when((SHAPE~>layerName=="M1")&&(bx1==2.76&&by1==4.78)||(bx1==2.76&&by1==1.01)
		bbox=list(ixy1-0.09:by1 ixy1-0.535:by2)
		dbSet(SHAPE bbox "bBox")) ; moves the M1 connecting the M2 which is connecting the internal net of R.3 C2 stat on left side
		when((SHAPE~>layerName=="M1")&&(SHAPE~>net~>name=="R.3")&&bx1==3.29&&by1==4.66
		when(((cordr3NPx2-0.06)>cordR1x3)&&(Nr3Width>0.21)
		pnts=list(cordr3NPx2+0.01:y1 cordr3NPx2+0.01:y2 ixy1:y3 ixy1:y4))
		when(((cordr3NPx2-0.06)>cordR1x3)&&(Nr3Width<0.21)
		pnts=list(3.86:y1 3.86:y2 ixy1:y3 ixy1:y4))
		when(((cordr3NPx2-0.06)<=cordR1x3)
		pnts=list(cordR1x3+0.03:y1 cordR1x3+0.03:y2 ixy1:y3 ixy1:y4))
		dbSet(SHAPE pnts "points")
		ActualR3x=caadr(SHAPE~>bBox)) ; moves the M1 connecting the R.3 input from the middle of the R.3 gate to the input of the internal chains of C2 gate
		when((SHAPE~>layerName=="M1")&&(bx1==3.41&&by1==1.01)||(bx1==3.41&&by1==4.78)
		bbox=list(ixy1+0.09:by1 ixy1+0.415:by2)
		dbSet(SHAPE bbox "bBox")) ; moves M1 connecting the M2 which is connecting the internal net on the right side of the C2 gate
		when((SHAPE~>layerName=="M2")&&((SHAPE~>net~>name=="_r.3")||(SHAPE~>net~>name=="_r.1"))&&((by1==3.77&&bx1==4.11)||(by1==0.485&&bx1==4.11))
		when(((cordR3NPx2-0.1)>=(ixy1+0.415))
		pnts=list(cordR3NPx2-0.07:y1 cordR3NPx2-0.07:y2))
		when(((cordR3NPx2-0.1)<(ixy1+0.415))
		pnts=list(ixy1+0.505:y1 ixy1+0.505:y2))
		dbSet(SHAPE pnts "points")
		Actualr1x=caar(SHAPE~>bBox)) ;Moves the M2 connecting the _r.3 and _r.1 with the NAND5 gate on the right side of the 2nd coloumn
		when((SHAPE~>layerName=="M1")&&((bx1==3.985&&by1==1.335)||(bx1==3.985&&by1==1.595)||(bx1==3.985&&by1==1.855)||(bx1==3.985&&by1==2.115)||(bx1==3.99&&by1==5.105)||(bx1==3.99&&by1==5.365)||(bx1==3.99&&by1==5.625)||(bx1==3.99&&by1==5.885))
		when(((cordR3NPx2-0.1)>=(ixy1+0.415))
		bbox=list(cordR3NPx2-0.11:by1 cordR3NPx2-0.03:by2))
		when(((cordR3NPx2-0.1)<(ixy1+0.415))
		bbox=list(cordR3NPx2-0.11:by1 ixy1+0.505:by2))
		dbSet(SHAPE bbox "bBox")) ;Moves the M1 connecting M2 wires of the _r.3 and _r.1 with the Poly_M1 vias of the R.3/R.1 INV gates
		when((SHAPE~>layerName=="M1")&&(SHAPE~>net~>name=="_r.1")&&(bx2==4.14&&by1==2.71)
		when(((cordR3NPx2-0.1)>=(ixy1+0.415))
		bbox=list(cordR3NPx2-0.11:by1 cordrvNPx2+0.06:by2))
		when(((cordR3NPx2-0.1)<(ixy1+0.415))
		bbox=list(ixy1+0.505:by1 cordrvNPx2+0.06:by2))
		dbSet(SHAPE bbox "bBox")) ;Moves the M1 connecting the _r.1 input of the NAND5 gate with the M2 wire
		when((SHAPE~>layerName=="M2")&&((SHAPE~>net~>name=="L.1")||(SHAPE~>net~>name=="R.e"))&&((by1==2.925&&bx1==4.25)||(by1==0.46&&bx1==4.25))
		when(((cordr3NPx2-0.06)>cordR1x3)&&(Nr3Width>0.21)
		pnts=list(cordr3NPx2+0.01:y1 cordr3NPx2+0.01:y2))
		when(((cordr3NPx2-0.06)>cordR1x3)&&(Nr3Width<0.21)
		pnts=list(3.86:y1 3.86:y2))
		when(((cordr3NPx2-0.06)<=cordR1x3)
		pnts=list(cordR1x3+0.03:y1 cordR1x3+0.03:y2))
		dbSet(SHAPE pnts "points")) ; Moves the M2 connecting to the L.1/R.e inputs on the right side of the C2 gates in the 2nd coloum
		when((SHAPE~>layerName=="M1")&&(bx1==2.93&&by1==2.31)
		when(((cordr3NPx2-0.06)>cordR1x3)&&(Nr3Width>0.21)
		pnts=list(ixy1-0.385:y1 cordr3NPx2+0.04:y2))
		when(((cordr3NPx2-0.06)>cordR1x3)&&(Nr3Width<0.21)
		pnts=list(ixy1-0.385:y1 3.89:y2))
		when(((cordr3NPx2-0.06)<=cordR1x3)
		pnts=list(ixy1-0.385:y1 cordR1x3+0.06:y2))
		dbSet(SHAPE pnts "points")) ; Moves M1 connecting the two M2's further connecting the L.1 net in the 2nd coloumn of the gates
		when((SHAPE~>layerName=="M1")&&(bx1==1.64&&by1==3.87)
		when(((cordr3NPx2-0.06)>cordR1x3)&&(Nr3Width>0.21)
		pnts=list(cordLex2-0.055:y1 ixy1:y2))
		when(((cordr3NPx2-0.06)>cordR1x3)&&(Nr3Width<0.21)
		pnts=list(cordLex2-0.055:y1 ixy1:y2))
		when(((cordr3NPx2-0.06)<=cordR1x3)
		pnts=list(cordLex2-0.055:y1 ixy1:y2))
		dbSet(SHAPE pnts "points")) ; Moves M1 connecting the two M2's further connecting the rv net in the centre of the gates in the two coloumns
		when((SHAPE~>layerName=="M1")&&(by1==0.425&&by2==0.745)||(by1==4.17&&by2==4.545)
		when(((cordr3NPx2-0.06)>cordR1x3)&&(Nr3Width>0.21)
		bbox=list(cordr3NPx2-0.02:by1 cordr3NPx2+0.04:by2))
		when(((cordr3NPx2-0.06)>cordR1x3)&&(Nr3Width<0.21)
		bbox=list(3.83:by1 3.89:by2))
		when(((cordr3NPx2-0.06)<=cordR1x3)
		bbox=list(cordR1x3:by1 cordR1x3+0.06:by2))
		dbSet(SHAPE bbox "bBox")) ; Moves the M1 connecting the L.1/R.e inputs on the right side of the C2 gates in between the 2 Poly_M1 vias
		when((SHAPE~>layerName=="M1")&&(bx1==0.1&&by1==3.22)
		pnts=list(0.97:y1 leftNPLUG+0.1:y2)
		dbSet(SHAPE pnts "points")) ; Moves the M1 connecting the NPLUG to the GND on the left side of the gate in the 1st  coloumn
		when((SHAPE~>layerName=="M1")&&(bx1==3.715&&by1==2.44)
		pnts=list(ixy1+0.09:y1 rightNPLUG-0.13:y2 rightNPLUG-0.13:y3)
		dbSet(SHAPE pnts "points")) ; Moves the M1 connecting the NPLUG to the GND on the right side of the gate in the 2nd  coloumn
		when((SHAPE~>layerName=="M1")&&((bx1==3.12&&by1==0.49)||(bx1==3.12&&by1==4.26))
		when(((cordR3NPx2-0.1)>=(ixy1+0.415))
		bbox=list(ixy1-0.2:by1 cordR3NPx2-0.07:by2))
		when(((cordR3NPx2-0.1)<(ixy1+0.415))
		bbox=list(ixy1-0.2:by1 ixy1+0.505:by2))
		dbSet(SHAPE bbox "bBox")) ; Moves the M1 connecting to the output _r.1 of the C2 gates in the lower portion of the 2nd coloumn
		when((SHAPE~>layerName=="PO")&&((bx1==3.06&&by1==0.7)||(bx1==3.06&&by1==0.44)||(bx1==3.06&&by1==4.21)||(bx1==3.06&&by1==4.47)||(bx1==3.06&&by1==4.73))
		when(((cordr3NPx2-0.06)>cordR1x3)&&(Nr3Width>0.21)
		bbox=list(ixy1-0.2:by1 cordr3NPx2+0.01:by2))
		when(((cordr3NPx2-0.06)>cordR1x3)&&(Nr3Width<0.21)
		bbox=list(ixy1-0.2:by1 3.86:by2))
		when(((cordr3NPx2-0.06)<=cordR1x3)
		bbox=list(ixy1-0.2:by1 cordR1x3+0.03:by2))
		dbSet(SHAPE bbox "bBox")) ; Moves the poly in the C2 gates connecting to the Poly_M1 vias on the right side of the C2 gates in the 2nd coloumn
		when((SHAPE~>layerName=="PO")&&(bx1==4.38&&bx2==4.42)
		when((cordrvNPx2+0.23)>=(rightpoly+0.07)
		bbox=list(cordrvNPx2+0.23:by1 cordrvNPx2+0.27:by2))
		when((cordrvNPx2+0.23)<(rightpoly+0.07)
		bbox=list(rightpoly+0.07:by1 rightpoly+0.11:by2))
		dbSet(SHAPE bbox "bBox")) ; moves CUT_POLY on the right of the leaf cell
		when((SHAPE~>layerName=="PO")&&(by2==6.24&&bx2==0.04)
		when(((cordnx1+0.06)<cordR2x4)&&(Nr2Width>0.21)
		bbox=list((cordnx1-0.1):by1 (cordnx1-0.14):by2))
		when(((cordnx1+0.06)<cordR2x4)&&(Nr2Width<0.21)
		bbox=list(0.6:by1 0.64:by2))
		when(((cordnx1+0.06)>=cordR2x4)
		bbox=list((cordR2x4-0.1):by1 (cordR2x4-0.14):by2))
		dbSet(SHAPE bbox "bBox")) ; moves CUT_POLY on the left of the leaf cell
		when((SHAPE~>layerName=="PP")&&(by1==3.12&&by2==3.645)
		when(((cordnx1+0.06)<cordR2x4)&&(Nr2Width>0.21)
		bbox=list((cordnx1-0.14):by1 (cordnx1-0.06):by2))
		when(((cordnx1+0.06)<cordR2x4)&&(Nr2Width<0.21)
		bbox=list(0.64:by1 0.56:by2))
		when(((cordnx1+0.06)>=cordR2x4)
		bbox=list((cordR2x4-0.14):by1 (cordR2x4-0.06):by2))
		dbSet(SHAPE bbox "bBox")) ; moves the PP on the left side of the NPLUG in the 1st coloumn
		when((SHAPE~>layerName=="PP")&&(by1==2.34&&by2==2.865)
		when((cordrvNPx2+0.23)>=(rightpoly+0.07)
		bbox=list(cordrvNPx2+0.19:by1 cordrvNPx2+0.27:by2))
		when((cordrvNPx2+0.23)<(rightpoly+0.07)
		bbox=list(rightpoly+0.03:by1 rightpoly+0.11:by2))
		dbSet(SHAPE bbox "bBox")) ; moves the PP on the right side of the NPLUG in the 2nd coloumn
		when((SHAPE~>layerName=="NP")&&(bx2==1.06&&by2==6.24)
		when(((cordnx1+0.06)<cordR2x4)&&(Nr2Width>0.21)
		pnts=list(x1:y1 (cordnx1-0.14):y2 (cordnx1-0.14):y3 (cordnx1+0.095):y4 (cordnx1+0.095):y5 (cordnx1-0.14):y6 (cordnx1-0.14):y7 x8:y8))
		when(((cordnx1+0.06)<cordR2x4)&&(Nr2Width<0.21)
		pnts=list(x1:y1 0.64:y2 0.64:y3 0.875:y4 0.875:y5 0.64:y6 0.64:y7 x8:y8))
		when(((cordnx1+0.06)>=cordR2x4)
		pnts=list(x1:y1 (cordR2x4-0.14):y2 (cordR2x4-0.14):y3 (cordR2x4+0.095):y4 (cordR2x4+0.095):y5 (cordR2x4-0.14):y6 (cordR2x4-0.14):y7 x8:y8))
		dbSet(SHAPE pnts "points")) ; moves the NP on the left side of the NPLUG in the 1st coloumn
		when((SHAPE~>layerName=="NP")&&(bx1==3.32&&by2==2.34)
		when((cordrvNPx2+0.23)>=(rightpoly+0.07)
		bbox=list(ixy1:by1 cordrvNPx2+0.27:by2))
		when((cordrvNPx2+0.23)<(rightpoly+0.07)
		bbox=list(ixy1:by1 rightpoly+0.11:by2))
		dbSet(SHAPE bbox "bBox")) ; moves the NP on the right side of the NPLUG in the lower half of the 2nd coloumn
		when((SHAPE~>layerName=="NP")&&(bx1==3.32&&by2==6.24)
		when((cordrvNPx2+0.23)>=(rightpoly+0.07)
		pnts=list(cordrvNPx2+0.035:y1 cordrvNPx2+0.035:y2 cordrvNPx2+0.27:y3 cordrvNPx2+0.27:y4 ixy1:y5 ixy1:y6))
		when((cordrvNPx2+0.23)<(rightpoly+0.07)
		pnts=list(rightpoly-0.125:y1 rightpoly-0.125:y2 rightpoly+0.11:y3 rightpoly+0.11:y4 ixy1:y5 ixy1:y6))
		dbSet(SHAPE pnts "points")) ; moves the NP on the right side of the NPLUG in the upper half of the 2nd coloumn
		when(((SHAPE~>layerName=="NW")||(SHAPE~>layerName=="PM"))&&((by1==3.86&&by2==6.11)||(by1==2.34&&by2==3.86)||(by1==0.13&&by2==2.34))
		bbox=list(bx1:by1 ixy1:by2)
		dbSet(SHAPE bbox "bBox")) ; moves the NW in the centre of the leaf cell w.r.t gates
		when((SHAPE~>layerName=="PP")&&((by1==0.17&&by2==2.34)||(by1==2.34&&by2==4.695))
		bbox=list(bx1:by1 ixy1:by2)
		dbSet(SHAPE bbox "bBox")) ; moves the PP in the centre of the leaf cell w.r.t gates
		when((SHAPE~>layerName=="PP")&&(bx1==1.06&&by1==4.695)
		when(cordR2x2>1.705
		pnts=list(ixy1:y1 x2:y2 x3:y3 cordR2x2+0.055:y4 cordR2x2+0.055:y5 cordR2x2+0.33:y6 cordR2x2+0.33:y7 ixy1:y8))
		when(cordR2x2<=1.705
		pnts=list(ixy1:y1 x2:y2 x3:y3 1.795:y4 1.795:y5 2.045:y6 2.045:y7 ixy1:y8))
		dbSet(SHAPE pnts "points")) ; moves the PP in the centre of the leaf cell w.r.t gates around the PPLUG region
		when((SHAPE~>layerName=="prBoundary")
		dbDeleteObject(SHAPE)
		when(((cordnx1+0.06)<cordR2x4)&&(Nr2Width>0.21)&&((cordrvNPx2+0.23)>=(rightpoly+0.07))
		pnts=list((cordnx1-0.14):by1 (cordnx1-0.14):by2 cordrvNPx2+0.27:by2 cordrvNPx2+0.27:by1))
		when(((cordnx1+0.06)<cordR2x4)&&(Nr2Width<0.21)&&((cordrvNPx2+0.23)>=(rightpoly+0.07))
		pnts=list(0.6:by1 0.6:by2 cordrvNPx2+0.27:by2 cordrvNPx2+0.27:by1))
		when(((cordnx1+0.06)>=cordR2x4)&&((cordrvNPx2+0.23)>=(rightpoly+0.07))
		pnts=list((cordR2x4-0.14):by1 (cordR2x4-0.14):by2 cordrvNPx2+0.27:by2 cordrvNPx2+0.27:by1))
		when(((cordnx1+0.06)<cordR2x4)&&(Nr2Width>0.21)&&((cordrvNPx2+0.23)<(rightpoly+0.07))
		pnts=list((cordnx1-0.14):by1 (cordnx1-0.14):by2 rightpoly+0.11:by2 rightpoly+0.11:by1))
		when(((cordnx1+0.06)<cordR2x4)&&(Nr2Width<0.21)&&((cordrvNPx2+0.23)<(rightpoly+0.07))
		pnts=list(0.6:by1 0.6:by2 rightpoly+0.11:by2 rightpoly+0.11:by1))
		when(((cordnx1+0.06)>=cordR2x4)&&((cordrvNPx2+0.23)<(rightpoly+0.07))
		pnts=list((cordR2x4-0.14):by1 (cordR2x4-0.14):by2 rightpoly+0.11:by2 rightpoly+0.11:by1))
		dbCreatePRBoundary(CellView pnts)) ;mover the prBoundary w.r.t the new parameters
		when((SHAPE~>layerName=="M3")&&((by1==0.025&&by2==0.095)||(by1==1.465&&by2==1.535)||(by1==1.585&&by2==1.655)||(by1==3.025&&by2==3.095)||(by1==3.145&&by2==3.215)||(by1==4.585&&by2==4.655)||(by1==4.705&&by2==4.775)||(by1==6.145&&by2==6.215))
		when(((cordnx1+0.06)<cordR2x4)&&(Nr2Width>0.21)&&((cordrvNPx2+0.23)>=(rightpoly+0.07))
		bbox=list((cordnx1-0.14):by1 cordrvNPx2+0.27:by2))
		when(((cordnx1+0.06)<cordR2x4)&&(Nr2Width<0.21)&&((cordrvNPx2+0.23)>=(rightpoly+0.07))
		bbox=list(0.6:by1 cordrvNPx2+0.27:by2))
		when(((cordnx1+0.06)>=cordR2x4)&&((cordrvNPx2+0.23)>=(rightpoly+0.07))
		bbox=list((cordR2x4-0.14):by1 cordrvNPx2+0.27:by2))
		when(((cordnx1+0.06)<cordR2x4)&&(Nr2Width>0.21)&&((cordrvNPx2+0.23)<(rightpoly+0.07))
		bbox=list((cordnx1-0.14):by1 rightpoly+0.11:by2))
		when(((cordnx1+0.06)<cordR2x4)&&(Nr2Width<0.21)&&((cordrvNPx2+0.23)<(rightpoly+0.07))
		bbox=list(0.6:by1 rightpoly+0.11:by2))
		when(((cordnx1+0.06)>=cordR2x4)&&((cordrvNPx2+0.23)<(rightpoly+0.07))
		bbox=list((cordR2x4-0.14):by1 rightpoly+0.11:by2))
		LeftLeaf=caar(bbox)
		RightLeaf=caadr(bbox)-LeftLeaf
		dbSet(SHAPE bbox "bBox")) ;moves the M3 GND/Vdd power wires
		when((SHAPE~>layerName=="M3")&&((bx1==0.04&&by1==0.295)||(bx1==0.04&&by1==2.895)||(bx1==0.04&&by1==4.455))
		when(((cordnx1+0.06)<cordR2x4)&&(Nr2Width>0.21)
		bbox=list((cordnx1-0.1):by1 bx2:by2))
		when(((cordnx1+0.06)<cordR2x4)&&(Nr2Width<0.21)
		bbox=list(0.6:by1 bx2:by2))
		when(((cordnx1+0.06)>=cordR2x4)
		bbox=list((cordR2x4-0.1):by1 bx2:by2))
		dbSet(SHAPE bbox "bBox")) ; moves the M3 pins L.0/L.2/L.e on the left side
		when((SHAPE~>layerName=="M3")&&(bx1==0.04&&by1==1.855)
		when(((cordnx1+0.06)<cordR2x4)&&(Nr2Width>0.21)
		bbox=list((cordnx1-0.1):by1 ixy1-0.385:by2))
		when(((cordnx1+0.06)<cordR2x4)&&(Nr2Width<0.21)
		bbox=list(0.6:by1 ixy1-0.385:by2))
		when(((cordnx1+0.06)>=cordR2x4)
		bbox=list((cordR2x4-0.1):by1 ixy1-0.385:by2))
		dbSet(SHAPE bbox "bBox")) ; moves the M3 pins L.1 on the left side
		when((SHAPE~>layerName=="M3")&&(bx1==0.04&&by1==4.975)
		when(((cordnx1+0.06)<cordR2x4)&&(Nr2Width>0.21)
		bbox=list((cordnx1-0.1):by1 cordR2x3+0.15:by2))
		when(((cordnx1+0.06)<cordR2x4)&&(Nr2Width<0.21)
		bbox=list(0.6:by1 cordR2x3+0.15:by2))
		when(((cordnx1+0.06)>=cordR2x4)
		bbox=list((cordR2x4-0.1):by1 cordR2x3+0.15:by2))
		dbSet(SHAPE bbox "bBox")) ; moves the M3 pins L.3 on the left side
		when((SHAPE~>layerName=="M3")&&(bx1==1.435&&by1==0.295)
		when((cordrvNPx2+0.23)>=(rightpoly+0.07)
		bbox=list(bx1:by1 cordrvNPx2+0.23:by2))
		when((cordrvNPx2+0.23)<(rightpoly+0.07)
		bbox=list(bx1:by1 rightpoly+0.07:by2))
		dbSet(SHAPE bbox "bBox")) ; moves the M3 pins R.0 on the right side
		when((SHAPE~>layerName=="M3")&&(bx1==3.32&&by1==1.855)
		when((cordrvNPx2+0.23)>=(rightpoly+0.07)
		bbox=list(ixy1:by1 cordrvNPx2+0.23:by2))
		when((cordrvNPx2+0.23)<(rightpoly+0.07)
		bbox=list(ixy1:by1 rightpoly+0.07:by2))
		dbSet(SHAPE bbox "bBox")) ; moves the M3 pins R.1 on the right side
		when((SHAPE~>layerName=="M3")&&(bx1==2.09&&by1==2.895)
		when((cordR2x3+0.28>=cordLex2-0.055)
		when(((cordnr3x1-0.06)>cordR1x3)&&(Nr3Width>0.21)&&((cordrvNPx2+0.23)>=(rightpoly+0.07))
		bbox=list((cordR2x3+0.28):by1 cordrvNPx2+0.23:by2))
		when(((cordnr3x1-0.06)>cordR1x3)&&(Nr3Width>0.21)&&((cordrvNPx2+0.23)<(rightpoly+0.07))
		bbox=list((cordR2x3+0.28):by1 rightpoly+0.07:by2))
		when(((cordnr3x1-0.06)>cordR1x3)&&(Nr3Width<0.21)&&((cordrvNPx2+0.23)>=(rightpoly+0.07))
		bbox=list(cordR2x3+0.28:by1 cordrvNPx2+0.23:by2))
		when(((cordnr3x1-0.06)>cordR1x3)&&(Nr3Width<0.21)&&((cordrvNPx2+0.23)<(rightpoly+0.07))
		bbox=list(cordR2x3+0.28:by1 rightpoly+0.07:by2))
		when(((cordnr3x1-0.06)<=cordR1x3)&&((cordrvNPx2+0.23)>=(rightpoly+0.07))
		bbox=list((cordR2x3+0.28):by1 cordrvNPx2+0.23:by2))
		when(((cordnr3x1-0.06)<=cordR1x3)&&((cordrvNPx2+0.23)<(rightpoly+0.07))
		bbox=list((cordR2x3+0.28):by1 rightpoly+0.07:by2)))
		when((cordR2x3+0.28<cordLex2-0.055)
		when(((cordnr3x1-0.06)>cordR1x3)&&(Nr3Width>0.21)&&((cordrvNPx2+0.23)>=(rightpoly+0.07))
		bbox=list((cordLex2+0.075):by1 cordrvNPx2+0.23:by2))
		when(((cordnr3x1-0.06)>cordR1x3)&&(Nr3Width>0.21)&&((cordrvNPx2+0.23)<(rightpoly+0.07))
		bbox=list((cordLex2+0.075):by1 rightpoly+0.07:by2))
		when(((cordnr3x1-0.06)>cordR1x3)&&(Nr3Width<0.21)&&((cordrvNPx2+0.23)>=(rightpoly+0.07))
		bbox=list(cordLex2+0.075:by1 cordrvNPx2+0.23:by2))
		when(((cordnr3x1-0.06)>cordR1x3)&&(Nr3Width<0.21)&&((cordrvNPx2+0.23)<(rightpoly+0.07))
		bbox=list(cordLex2+0.075:by1 rightpoly+0.07:by2))
		when(((cordnr3x1-0.06)<=cordR1x3)&&((cordrvNPx2+0.23)>=(rightpoly+0.07))
		bbox=list((cordLex2+0.075):by1 cordrvNPx2+0.23:by2))
		when(((cordnr3x1-0.06)<=cordR1x3)&&((cordrvNPx2+0.23)<(rightpoly+0.07))
		bbox=list((cordLex2+0.075):by1 rightpoly+0.07:by2)))
		dbSet(SHAPE bbox "bBox")) ; moves the M3 pins R.e on the right side
		when((SHAPE~>layerName=="M3")&&(bx1==1.435&&by1==4.455)
		when((cordrvNPx2+0.23)>=(rightpoly+0.07)
		bbox=list(1.45:by1 cordrvNPx2+0.23:by2))
		when((cordrvNPx2+0.23)<(rightpoly+0.07)
		bbox=list(1.45:by1 rightpoly+0.07:by2))
		dbSet(SHAPE bbox "bBox")) ; moves the M3 pins R.2 on the right side
		when((SHAPE~>layerName=="M3")&&(bx1==3.32&&by1==4.975)
		when((cordrvNPx2+0.23)>=(rightpoly+0.07)
		bbox=list(ixy1:by1 cordrvNPx2+0.23:by2))
		when((cordrvNPx2+0.23)<(rightpoly+0.07)
		bbox=list(ixy1:by1 rightpoly+0.07:by2))
		dbSet(SHAPE bbox "bBox")) ; moves the M3 pins R.3 on the right side

		when((SHAPE~>layerName=="M3")&&(bx1==0.04&&by1==3.415)
		when(((cordnx1+0.06)<cordR2x4)&&(Nr2Width>0.21)&&((cordrvNPx2+0.23)>=(rightpoly+0.07))
		bbox=list((cordnx1-0.1):by1 cordrvNPx2+0.23:by2))
		when(((cordnx1+0.06)<cordR2x4)&&(Nr2Width<0.21)&&((cordrvNPx2+0.23)>=(rightpoly+0.07))
		bbox=list(0.6:by1 cordrvNPx2+0.23:by2))
		when(((cordnx1+0.06)>=cordR2x4)&&((cordrvNPx2+0.23)>=(rightpoly+0.07))
		bbox=list((cordR2x4-0.1):by1 cordrvNPx2+0.23:by2))
		when(((cordnx1+0.06)<cordR2x4)&&(Nr2Width>0.21)&&((cordrvNPx2+0.23)<(rightpoly+0.07))
		bbox=list((cordnx1-0.1):by1 rightpoly+0.07:by2))
		when(((cordnx1+0.06)<cordR2x4)&&(Nr2Width<0.21)&&((cordrvNPx2+0.23)<(rightpoly+0.07))
		bbox=list(0.6:by1 rightpoly+0.07:by2))
		when(((cordnx1+0.06)>=cordR2x4)&&((cordrvNPx2+0.23)<(rightpoly+0.07))
		bbox=list((cordR2x4-0.1):by1 rightpoly+0.07:by2))
		dbSet(SHAPE bbox "bBox")) ; moves the RESET M3 pin
		when((SHAPE~>layerName=="PO")&&((bx1==0&&by2==0.08)||(bx1==0&&by2==0.21)||(bx1==0&&by2==0.34)||(bx1==0&&by2==0.47)||(bx1==0&&by2==0.6)||(bx1==0&&by2==0.73)||(bx1==0&&by2==0.86)||(bx1==0&&by2==0.99)||(bx1==0&&by2==1.12)||(bx1==0&&by2==1.25)||(bx1==0&&by2==1.38)||(bx1==0&&by2==1.51)||(bx1==0&&by2==1.64)||(bx1==0&&by2==1.77)||(bx1==0&&by2==1.9)||(bx1==0&&by2==2.03)||(bx1==0&&by2==2.16)||(bx1==0&&by2==2.29)||(bx1==0&&by2==2.42)||(bx1==0&&by2==2.55)||(bx1==0&&by2==2.94)||(bx1==0&&by2==3.07)||(bx1==0&&by2==3.46)||(bx1==0&&by2==3.59)||(bx1==0&&by2==3.72)||(bx1==0&&by2==3.85)||(bx1==0&&by2==3.98)||(bx1==0&&by2==4.11)||(bx1==0&&by2==4.24)||(bx1==0&&by2==4.37)||(bx1==0&&by2==4.5)||(bx1==0&&by2==4.63)||(bx1==0&&by2==4.76)||(bx1==0&&by2==4.89)||(bx1==0&&by2==5.28)||(bx1==0&&by2==5.41)||(bx1==0&&by2==5.54)||(bx1==0&&by2==5.67)||(bx1==0&&by2==5.8)||(bx1==0&&by2==5.93)||(bx1==0&&by2==6.06)||(bx1==0&&by2==6.19))
		when(((cordnx1+0.06)<cordR2x4)&&(Nr2Width>0.21)&&((cordrvNPx2+0.23)>=(rightpoly+0.07))
		bbox=list((cordnx1-0.14):by1 cordrvNPx2+0.27:by2))
		when(((cordnx1+0.06)<cordR2x4)&&(Nr2Width<0.21)&&((cordrvNPx2+0.23)>=(rightpoly+0.07))
		bbox=list(0.6:by1 cordrvNPx2+0.27:by2))
		when(((cordnx1+0.06)>=cordR2x4)&&((cordrvNPx2+0.23)>=(rightpoly+0.07))
		bbox=list((cordR2x4-0.14):by1 cordrvNPx2+0.27:by2))
		when(((cordnx1+0.06)<cordR2x4)&&(Nr2Width>0.21)&&((cordrvNPx2+0.23)<(rightpoly+0.07))
		bbox=list((cordnx1-0.14):by1 rightpoly+0.11:by2))
		when(((cordnx1+0.06)<cordR2x4)&&(Nr2Width<0.21)&&((cordrvNPx2+0.23)<(rightpoly+0.07))
		bbox=list(0.6:by1 rightpoly+0.11:by2))
		when(((cordnx1+0.06)>=cordR2x4)&&((cordrvNPx2+0.23)<(rightpoly+0.07))
		bbox=list((cordR2x4-0.14):by1 rightpoly+0.11:by2))
		dbSet(SHAPE bbox "bBox")) ; moves the dummy poly grids
		when((SHAPE~>layerName=="PO")&&((bx1==0&&by2==2.68)||(bx1==0&&by2==2.81))
		when(((cordnx1+0.06)<cordR2x4)&&(Nr2Width>0.21)&&((cordrvNPx2+0.23)>=(rightpoly+0.07))
		bbox=list((cordnx1-0.14):by1 cordrvNPx2+0.035:by2))
		when(((cordnx1+0.06)<cordR2x4)&&(Nr2Width<0.21)&&((cordrvNPx2+0.23)>=(rightpoly+0.07))
		bbox=list(0.6:by1 cordrvNPx2+0.035:by2))
		when(((cordnx1+0.06)>=cordR2x4)&&((cordrvNPx2+0.23)>=(rightpoly+0.07))
		bbox=list((cordR2x4-0.14):by1 cordrvNPx2+0.035:by2))
		when(((cordnx1+0.06)<cordR2x4)&&(Nr2Width>0.21)&&((cordrvNPx2+0.23)<(rightpoly+0.07))
		bbox=list((cordnx1-0.14):by1 rightpoly-0.125:by2))
		when(((cordnx1+0.06)<cordR2x4)&&(Nr2Width<0.21)&&((cordrvNPx2+0.23)<(rightpoly+0.07))
		bbox=list(0.6:by1 rightpoly-0.125:by2))
		when(((cordnx1+0.06)>=cordR2x4)&&((cordrvNPx2+0.23)<(rightpoly+0.07))
		bbox=list((cordR2x4-0.14):by1 rightpoly-0.125:by2))
		dbSet(SHAPE bbox "bBox")) ; moves the 2 dummy polys near the 2nd NPLUG on the right side in 2nd coloumn
		when((SHAPE~>layerName=="PO")&&((bx1==0.4&&by2==3.2)||(bx1==0.4&&by2==3.33))
		when(((cordnx1+0.06)<cordR2x4)&&(Nr2Width>0.21)&&((cordrvNPx2+0.23)>=(rightpoly+0.07))
		bbox=list((cordnx1+0.095):by1 cordrvNPx2+0.27:by2))
		when(((cordnx1+0.06)<cordR2x4)&&(Nr2Width<0.21)&&((cordrvNPx2+0.23)>=(rightpoly+0.07))
		bbox=list(0.695:by1 cordrvNPx2+0.27:by2))
		when(((cordnx1+0.06)>=cordR2x4)&&((cordrvNPx2+0.23)>=(rightpoly+0.07))
		bbox=list((cordR2x4+0.095):by1 cordrvNPx2+0.27:by2))
		when(((cordnx1+0.06)<cordR2x4)&&(Nr2Width>0.21)&&((cordrvNPx2+0.23)<(rightpoly+0.07))
		bbox=list((cordnx1+0.095):by1 rightpoly+0.11:by2))
		when(((cordnx1+0.06)<cordR2x4)&&(Nr2Width<0.21)&&((cordrvNPx2+0.23)<(rightpoly+0.07))
		bbox=list(0.695:by1 rightpoly+0.11:by2))
		when(((cordnx1+0.06)>=cordR2x4)&&((cordrvNPx2+0.23)<(rightpoly+0.07))
		bbox=list((cordR2x4+0.095):by1 rightpoly+0.11:by2))
		dbSet(SHAPE bbox "bBox")) ; moves the 2 dummy polys near the 1st NPLUG on the left side in 1st coloumn
		when((SHAPE~>layerName=="PO")&&((bx1==2.46&&by2==5.15)||(bx1==2.46&&by2==5.02))
		when(cordR2x2>1.705
		when(((cordnx1+0.06)<cordR2x4)&&(Nr2Width>0.21)&&((cordrvNPx2+0.23)>=(rightpoly+0.07))
		bbox=list(cordR2x2+0.33:by1 cordrvNPx2+0.27:by2))
		when(((cordnx1+0.06)<cordR2x4)&&(Nr2Width<0.21)&&((cordrvNPx2+0.23)>=(rightpoly+0.07))
		bbox=list(cordR2x2+0.33:by1 cordrvNPx2+0.27:by2))
		when(((cordnx1+0.06)>=cordR2x4)&&((cordrvNPx2+0.23)>=(rightpoly+0.07))
		bbox=list(cordR2x2+0.33:by1 cordrvNPx2+0.27:by2))
		when(((cordnx1+0.06)<cordR2x4)&&(Nr2Width>0.21)&&((cordrvNPx2+0.23)<(rightpoly+0.07))
		bbox=list(cordR2x2+0.33:by1 rightpoly+0.11:by2))
		when(((cordnx1+0.06)<cordR2x4)&&(Nr2Width<0.21)&&((cordrvNPx2+0.23)<(rightpoly+0.07))
		bbox=list(cordR2x2+0.33:by1 rightpoly+0.11:by2))
		when(((cordnx1+0.06)>=cordR2x4)&&((cordrvNPx2+0.23)<(rightpoly+0.07))
		bbox=list(cordR2x2+0.33:by1 rightpoly+0.11:by2)))
		when(cordR2x2<1.705
		when(((cordnx1+0.06)<cordR2x4)&&(Nr2Width>0.21)&&((cordrvNPx2+0.23)>=(rightpoly+0.07))
		bbox=list(1.98:by1 cordrvNPx2+0.27:by2))
		when(((cordnx1+0.06)<cordR2x4)&&(Nr2Width<0.21)&&((cordrvNPx2+0.23)>=(rightpoly+0.07))
		bbox=list(1.98:by1 cordrvNPx2+0.27:by2))
		when(((cordnx1+0.06)>=cordR2x4)&&((cordrvNPx2+0.23)>=(rightpoly+0.07))
		bbox=list(1.98:by1 cordrvNPx2+0.27:by2))
		when(((cordnx1+0.06)<cordR2x4)&&(Nr2Width>0.21)&&((cordrvNPx2+0.23)<(rightpoly+0.07))
		bbox=list(1.98:by1 rightpoly+0.11:by2))
		when(((cordnx1+0.06)<cordR2x4)&&(Nr2Width<0.21)&&((cordrvNPx2+0.23)<(rightpoly+0.07))
		bbox=list(1.98:by1 rightpoly+0.11:by2))
		when(((cordnx1+0.06)>=cordR2x4)&&((cordrvNPx2+0.23)<(rightpoly+0.07))
		bbox=list(1.98:by1 rightpoly+0.11:by2)))
		dbSet(SHAPE bbox "bBox")) ;moves the poly on the right side of the PPLUG
		when((SHAPE~>layerName=="PO")&&((bx1==0&&by2==5.15)||(bx1==0&&by2==5.02))
		when(cordR2x2>1.705
		when(((cordnx1+0.06)<cordR2x4)&&(Nr2Width>0.21)&&((cordrvNPx2+0.23)>=(rightpoly+0.07))
		bbox=list((cordnx1-0.14):by1 cordR2x2:by2))
		when(((cordnx1+0.06)<cordR2x4)&&(Nr2Width<0.21)&&((cordrvNPx2+0.23)>=(rightpoly+0.07))
		bbox=list(0.6:by1 cordR2x2:by2))
		when(((cordnx1+0.06)>=cordR2x4)&&((cordrvNPx2+0.23)>=(rightpoly+0.07))
		bbox=list((cordR2x4-0.14):by1 cordR2x2:by2))
		when(((cordnx1+0.06)<cordR2x4)&&(Nr2Width>0.21)&&((cordrvNPx2+0.23)<(rightpoly+0.07))
		bbox=list((cordnx1-0.14):by1 cordR2x2:by2))
		when(((cordnx1+0.06)<cordR2x4)&&(Nr2Width<0.21)&&((cordrvNPx2+0.23)<(rightpoly+0.07))
		bbox=list(0.6:by1 cordR2x2:by2))
		when(((cordnx1+0.06)>=cordR2x4)&&((cordrvNPx2+0.23)<(rightpoly+0.07))
		bbox=list((cordR2x4-0.14):by1 cordR2x2:by2)))
		when(cordR2x2<1.705
		when(((cordnx1+0.06)<cordR2x4)&&(Nr2Width>0.21)&&((cordrvNPx2+0.23)>=(rightpoly+0.07))
		bbox=list((cordnx1-0.14):by1 1.82:by2))
		when(((cordnx1+0.06)<cordR2x4)&&(Nr2Width<0.21)&&((cordrvNPx2+0.23)>=(rightpoly+0.07))
		bbox=list(0.6:by1 1.82:by2))
		when(((cordnx1+0.06)>=cordR2x4)&&((cordrvNPx2+0.23)>=(rightpoly+0.07))
		bbox=list((cordR2x4-0.14):by1 1.82:by2))
		when(((cordnx1+0.06)<cordR2x4)&&(Nr2Width>0.21)&&((cordrvNPx2+0.23)<(rightpoly+0.07))
		bbox=list((cordnx1-0.14):by1 1.82:by2))
		when(((cordnx1+0.06)<cordR2x4)&&(Nr2Width<0.21)&&((cordrvNPx2+0.23)<(rightpoly+0.07))
		bbox=list(0.6:by1 1.82:by2))
		when(((cordnx1+0.06)>=cordR2x4)&&((cordrvNPx2+0.23)<(rightpoly+0.07))
		bbox=list((cordR2x4-0.14):by1 1.82:by2)))
		dbSet(SHAPE bbox "bBox")) ;moves the poly on the right side of the PPLUG

		when((SHAPE~>layerName=="NP")&&(bx1==1.06&&by2==0.17)
		bbox=list( bx1:(by1-0.13) ixy1:by2)
		dbCreateRect(CellView NWellLPP list(leftNPLUG:(by1-0.13) rightNPLUG:by2))
		dbSet(SHAPE bbox "bBox")) ; moves the NP layer in the bottom portion of the leaf cell and also draws NWell in the bottom portion
		when((SHAPE~>layerName=="NP")&&(by1==6.07&&by2==6.24)
		bbox=list( bx1:by1 ixy1:(by2+0.13) )
		dbCreateRect(CellView NWellLPP list(leftNPLUG:by1 rightNPLUG:(by2+0.13)))
		dbSet(SHAPE bbox "bBox")) ; moves the NP layer in the top portion of the leaf cell and also draws NWell in the top portion
		when(((SHAPE~>layerName=="CO")||(SHAPE~>layerName=="OD"))&&((by1==0.37&&by2==0.41)||(by1==0.365&&by2==0.415)||(by1==0.63&&by2==0.67)||(by1==0.625&&by2==0.675)||(by1==4.14&&by2==4.18)||(by1==4.135&&by2==4.185)||(by1==4.4&&by2==4.44)||(by1==4.395&&by2==4.445)||(by1==5.57&&by2==5.61)||(by1==5.565&&by2==5.615)||(by1==5.83&&by2==5.87)||(by1==5.825&&by2==5.875)||(by1==2.06&&by2==2.1)||(by1==2.055&&by2==2.105)||(by1==1.8&&by2==1.84)||(by1==1.795&&by2==1.845))
		dbDeleteObject(SHAPE)
		)

		))

	foreach(VIA CellView->vias
		(let (vx1 vy1 bx1 by1 bx2 by2 vx1 vy1 orgn pnts)
		bx1=caar(VIA~>bBox)
		by1=cadar(VIA~>bBox)
		bx2=caadr(VIA~>bBox)
		by2=cadadr(VIA~>bBox)
		vx1=car(VIA~>origin)
		vy1=cadr(VIA~>origin)
		when((VIA~>viaHeader~>viaDefName=="M2_M1")&& ((VIA~>net~>name=="_r.2")||(VIA~>net~>name=="_r.0"))&&(vx1==0.24)&&((vy1==5.745)||(vy1==1.975))
		when((ActualL2x+0.14)<=Actualr2x
		dbDeleteObject(VIA)
		when(((cordR2x4+0.07)<=0.545)
		pnts=(cordR2x4+0.07:vy1-0.025))
		when(((cordR2x4+0.07)>0.545)
		pnts=(0.545:vy1-0.025))
		        dbCreateParamInstByMasterName(CellView "tsmc28" "M2_M1a_O" "layout" nil pnts "R90" 1
	               list( list("column" "int" 1)
                     list("row" "int" 1)
                     list("layer1XDefOverride" "float" 0.005)
                     list("layer1YDefOverride" "float" 0.03)
                     list("layer2XDefOverride" "float" 0.03)
                     list("layer2YDefOverride" "float" 0.005) ) )))
		when((VIA~>viaHeader~>viaDefName=="M2_M1")&& ((VIA~>net~>name=="_r.2")||(VIA~>net~>name=="_r.0"))&&(vx1==0.24)
		when(ActualL2x+0.13>=Actualr2x
		when(((cordR2x4+0.07)<=0.545)
		orgn=(cordR2x4+0.07:vy1))
		when(((cordR2x4+0.07)>0.545)
		orgn=(0.545:vy1))
		dbSet(VIA orgn "origin"))
		when(ActualL2x+0.13<Actualr2x
		dbDeleteObject(VIA)
		when(((cordR2x4+0.07)<=0.545)
		orgn=(cordR2x4+0.07:vy1+0.025))
		when(((cordR2x4+0.07)>0.545)
		orgn=(0.545:vy1+0.025))
		        dbCreateParamInstByMasterName(CellView "tsmc28" "M2_M1a_O" "layout" nil orgn "R90" 1
	               list( list("column" "int" 1)
                     list("row" "int" 1)
                     list("layer1XDefOverride" "float" 0.005)
                     list("layer1YDefOverride" "float" 0.03)
                     list("layer2XDefOverride" "float" 0.03)
                     list("layer2YDefOverride" "float" 0.005) ) )))

		when(((VIA~>viaHeader~>viaDefName=="M2_M1")||(VIA~>viaHeader~>viaDefName=="M3_M2"))&& ((VIA~>net~>name=="L.2")||(VIA~>net~>name=="L.0"))&&(vx1==0.11)
		when(((cordnx1+0.06)<cordR2x4)&&(Nr2Width>0.21)&&((cordR2x4+0.07)>(cordnx1-0.01))
		orgn=(cordnx1-0.03:vy1))
		when(((cordnx1+0.06)<cordR2x4)&&(Nr2Width>0.21)&&((cordR2x4+0.07)<=(cordnx1-0.01))
		orgn=(0.415:vy1))
		when(((cordnx1+0.06)<cordR2x4)&&(Nr2Width<0.21)
		orgn=(0.415:vy1))
		when(((cordnx1+0.06)>=cordR2x4)&&((cordR2x4+0.07)<=0.545)
		orgn=(cordR2x4-0.03:vy1))
		when(((cordnx1+0.06)>=cordR2x4)&&((cordR2x4+0.07)>0.545)
		orgn=(0.415:vy1))
		dbSet(VIA orgn "origin"))
		when((VIA~>viaHeader~>viaDefName=="M2_M1")&& ((VIA~>net~>name=="_r.3")||(VIA~>net~>name=="_r.1"))&&(((vx1==4.14)&&(vy1==0.495))||((vx1==4.14)&&(vy1==4.265)))
		when(Actualr1x<cordr3NPx2
		dbDeleteObject(VIA))
		when(Actualr1x>=cordr3NPx2
		orgn=(Actualr1x+0.03:vy1)
		dbSet(VIA orgn "origin"))
		when(Actualr1x<cordr3NPx2
		pnts=(Actualr1x+0.03:vy1+0.025)
		        dbCreateParamInstByMasterName(CellView "tsmc28" "M2_M1a_O" "layout" nil pnts "R90" 1
	               list( list("column" "int" 1)
                     list("row" "int" 1)
                     list("layer1XDefOverride" "float" 0.005)
                     list("layer1YDefOverride" "float" 0.03)
                     list("layer2XDefOverride" "float" 0.03)
                     list("layer2YDefOverride" "float" 0.005) ) )
			))
		when((VIA~>viaHeader~>viaDefName=="M2_M1")&& ((VIA~>net~>name=="_r.3")||(VIA~>net~>name=="_r.1"))&&((vx1==4.14&&vy1==5.89)||(vx1==4.14&&vy1==5.63)||(vx1==4.14&&vy1==5.37)||(vx1==4.14&&vy1==5.11))
		when(Actualr1x+0.13>ActualR3x
		orgn=(Actualr1x+0.03:vy1)
		dbSet(VIA orgn "origin"))
		when(Actualr1x+0.13<=ActualR3x
		dbDeleteObject(VIA))
		orgn=(Actualr1x+0.03:vy1+0.025)
		        dbCreateParamInstByMasterName(CellView "tsmc28" "M2_M1a_O" "layout" nil orgn "R90" 1
	               list( list("column" "int" 1)
                     list("row" "int" 1)
                     list("layer1XDefOverride" "float" 0.005)
                     list("layer1YDefOverride" "float" 0.03)
                     list("layer2XDefOverride" "float" 0.03)
                     list("layer2YDefOverride" "float" 0.005) ) ))

		when((VIA~>viaHeader~>viaDefName=="M2_M1")&& ((VIA~>net~>name=="_r.3")||(VIA~>net~>name=="_r.1"))&&((vx1==4.14&&vy1==1.365)||(vx1==4.14&&vy1==1.625)||(vx1==4.14&&vy1==1.885)||(vx1==4.14&&vy1==2.145)||(vx1==4.14&&vy1==2.74)||(vx1==4.14&&vy1==3.91))
		orgn=(Actualr1x+0.03:vy1)
		dbSet(VIA orgn "origin"))
		when((VIA~>viaHeader~>viaDefName=="M2_M1")&& (VIA~>net~>name=="rv")&&(vx1==1.655)
		orgn=(cordLex2-0.055:vy1)
		dbSet(VIA orgn "origin"))
		when(((VIA~>viaHeader~>viaDefName=="M2_M1")||(VIA~>viaHeader~>viaDefName=="M3_M2"))&&(VIA~>net~>name=="_RESET")&&(vx1==1.485)
		orgn=(cordResx2-0.08:vy1)
		dbSet(VIA orgn "origin"))
		when(((VIA~>viaHeader~>viaDefName=="M2_M1")||(VIA~>viaHeader~>viaDefName=="M3_M2"))&&(vx1==3.32)
		orgn=(ixy1:vy1)
		dbSet(VIA orgn "origin"))
		when(((VIA~>viaHeader~>viaDefName=="M2_M1")||(VIA~>viaHeader~>viaDefName=="M3_M2"))&&(VIA~>net~>name=="L.3")&&(vx1==1.97)
		orgn=(cordR2x3+0.15:vy1)
		dbSet(VIA orgn "origin"))
		when(((VIA~>viaHeader~>viaDefName=="M2_M1")||(VIA~>viaHeader~>viaDefName=="M3_M2"))&&(vx1==2.1)
		when((cordR2x3+0.28>=cordLex2-0.055)
		orgn=(cordR2x3+0.28:vy1))
		when((cordR2x3+0.28<cordLex2-0.055)
		orgn=(cordLex2+0.075:vy1))
		dbSet(VIA orgn "origin")) ; Moves the M2_M1/M3_M2 vias of R.e
		when(((VIA~>viaHeader~>viaDefName=="M2_M1")||(VIA~>viaHeader~>viaDefName=="M3_M2"))&&(vx1==4.28)
		when(((cordr3NPx2-0.06)>cordR1x3)&&(Nr3Width>0.21)
		orgn=(cordr3NPx2+0.01:vy1))
		when(((cordr3NPx2-0.06)>cordR1x3)&&(Nr3Width<0.21)
		orgn=(3.86:vy1))
		when(((cordr3NPx2-0.06)<=cordR1x3)
		orgn=(cordR1x3+0.03:vy1))
		dbSet(VIA orgn "origin")) ; Moves the M2_M1/M3_M2 vias of R.e/L.1 on the right side of the C2 gates in the 2nd coloumn
		when(((VIA~>viaHeader~>viaDefName=="M2_M1")||(VIA~>viaHeader~>viaDefName=="M3_M2"))&&(vx1==2.935)
		orgn=(ixy1-0.385:vy1)
		dbSet(VIA orgn "origin"))
		when((VIA~>viaHeader~>viaDefName=="M2_M1")&&(vx1==2.815)
		orgn=(ixy1-0.505:vy1)
		dbSet(VIA orgn "origin"))
		when((VIA~>viaHeader~>viaDefName=="M2_M1")&&(vx1==3.705)
		orgn=(ixy1+0.385:vy1)
		dbSet(VIA orgn "origin"))
		when((VIA~>viaHeader~>viaDefName=="M2_M1")&&(vx1==4.14)
		when(((cordR3NPx2-0.1)>=(ixy1+0.415))
		orgn=(cordR3NPx2-0.07:vy1))
		when(((cordR3NPx2-0.1)<(ixy1+0.415))
		orgn=(ixy1+0.505:vy1))
		dbSet(VIA orgn "origin"))
		when((VIA~>viaHeader~>viaDefName=="M3_M2_R_H")&& (vx1==3.515)
		orgn=(ixy1+0.195:vy1)
		dbSet(VIA orgn "origin"))
		when((VIA~>viaHeader~>viaDefName=="M3_M2_R_H")&& (vx1==3.125)
		orgn=(ixy1-0.195:vy1)
		dbSet(VIA orgn "origin"))
		))
	))

(defun MakeBuffer_FullHeight (CellView ViewName)
	(let (text parameter1 parameter2 parameter3 parameter4 cordM2_M1 INST SHAPE VIA Inst_Reset cordx cordx1 cordx2 cordR3y2 cordP2x cordP2x1 cordP1x cordP1x1 cordP0x cordP0x1 cordNx cordNx1 cordN2x cordN2x1 cordN1x cordN1x1 cordN0x cordN0x1 cordNx2 cordLx cordLx1 cordLx2 cordrvx cordrvx2 cordrvPx cordrv1 cordrv2 cordR2 cordR0 cordRx1 ActualcordRx1 ActualcordRx0 ActualResx ActualReset Actualcordr3x cordLe ResNWidth ResPWidth ResetNWidth R3NWidth R2PWidth LePWidth cordR2y2 cordR1y2 cordR1y1 cordR0y1 cordLey2 ActualPolyLeft ActualrvLeft cordR2x1 cordR0x1)
	fl = infile("Parameter.txt")
	while( gets(k fl) != nil
  	text = parseString( k " \n")
	parameter1 = nth(0 text)
	parameter2 = nth(1 text)
	parameter3 = nth(2 text)
	parameter4 = nth(3 text)

; setting instance parameters as per the spec file
	foreach(INST CellView->instances
		(let (N P Nparam Pparam paraN1 paraN2 paraP1 paraP2 paraP3 paraP4 paraP5 paraP6 paraP7 paraP8 paraP9 paraP10)
		when( (INST->cellName=="gate.INV.0-L1_1-R")&& (INST->name==parameter1)
		N=evalstring(parameter3)
		Nparam=N/1000000
		P=evalstring(parameter4)
		Pparam=P/1000000
		when((INST->cellName=="gate.INV.0-L1_1-R") && (INST->name=="R.3")
			R3NWidth=N)
		when((INST->cellName=="gate.INV.0-L1_1-R") && (INST->name=="R.2")
			R2PWidth=P)
		when((INST->cellName=="gate.INV.0-L1_1-R") && (INST->name=="Reset")
			ResPWidth=P
			ResNWidth=N)
		when((INST->cellName=="gate.INV.0-L1_1-R") && (INST->name=="L.e")
			LePWidth=P)
		when((INST->cellName=="gate.INV.0-L1_1-R") && (INST->name=="_Reset")
			ResetNWidth=N)
		dbReplaceProp(INST "NW1" "float" Nparam)
		dbReplaceProp(INST "PW1" "float" Pparam)
		)
		when( ( (INST->cellName=="stack.NMOS_CHAIN_2.0-L1-R") || (INST->cellName=="stack.NMOS_CHAIN_5.0-L1-R") || (INST->cellName=="stack.PMOS_CHAIN_2.0-L1-R"))
		paraN1 = strcat( parameter1 "." "N1")
		paraN2 = strcat( parameter1 "." "N2")
		paraP1 = strcat( parameter1 "." "P1")
		paraP2 = strcat( parameter1 "." "P2")
		when(((INST->name==paraN1) || (INST->name==paraP1) || (INST->name==paraN2) || (INST->name==paraP2) )
		N=evalstring(parameter3)
		Nparam=N/2000000
		P=evalstring(parameter4)
		Pparam=P/2000000
		dbReplaceProp(INST "NW2" "float" Nparam)
		dbReplaceProp(INST "NW5" "float" Nparam)
		dbReplaceProp(INST "PW2" "float" Pparam)
		))
		when( INST->cellName=="stack.PMOS_CHAIN_1.0-L1-R"
		paraP1 = strcat( parameter1 "." "P1")
		paraP2 = strcat( parameter1 "." "P2")
		paraP3 = strcat( parameter1 "." "P3")
		paraP4 = strcat( parameter1 "." "P4")
		paraP5 = strcat( parameter1 "." "P5")
		paraP6 = strcat( parameter1 "." "P6")
		paraP7 = strcat( parameter1 "." "P7")
		paraP8 = strcat( parameter1 "." "P8")
		paraP9 = strcat( parameter1 "." "P9")
		paraP10 = strcat( parameter1 "." "P10")
		when(((INST->name==paraP1) || (INST->name==paraP2) || (INST->name==paraP3) || (INST->name==paraP4) || (INST->name==paraP5) || (INST->name==paraP6) || (INST->name==paraP7) || (INST->name==paraP8) || (INST->name==paraP9) || (INST->name==paraP10) )
		P=evalstring(parameter4)
		Pparam=P/2000000
		dbReplaceProp(INST "PW1" "float" Pparam)
		))
	)))

	foreach(INST CellView->instances
		when(((INST->cellName=="stack.PMOS_CHAIN_2.0-L1-R") && (INST->name=="_r.3.P1"))
		cordx=caadr(INST~>bBox)
		cordx1=cordx-0.02
		cordx2=cordx1+0.06)
		when(((INST->cellName=="stack.PMOS_CHAIN_2.0-L1-R") && (INST->name=="_r.2.P1"))
		cordP2x=caadr(INST~>bBox)
		cordP2x1=cordP2x-0.02)
		when(((INST->cellName=="stack.PMOS_CHAIN_2.0-L1-R") && (INST->name=="_r.1.P1"))
		cordP1x=caadr(INST~>bBox)
		cordP1x1=cordP1x-0.02)
		when(((INST->cellName=="stack.PMOS_CHAIN_2.0-L1-R") && (INST->name=="_r.0.P1"))
		cordP0x=caadr(INST~>bBox)
		cordP0x1=cordP0x-0.02)
		when(((INST->cellName=="stack.NMOS_CHAIN_2.0-L1-R") && (INST->name=="_r.3.N1"))
		cordNx=caar(INST~>bBox)
		cordNx1=cordNx+0.02
		cordNx2=cordNx1-0.06)
		when(((INST->cellName=="stack.NMOS_CHAIN_2.0-L1-R") && (INST->name=="_r.2.N1"))
		cordN2x=caar(INST~>bBox)
		cordN2x1=cordN2x+0.02)
		when(((INST->cellName=="stack.NMOS_CHAIN_2.0-L1-R") && (INST->name=="_r.1.N1"))
		cordN1x=caar(INST~>bBox)
		cordN1x1=cordN1x+0.02)
		when(((INST->cellName=="stack.NMOS_CHAIN_2.0-L1-R") && (INST->name=="_r.0.N1"))
		cordN0x=caar(INST~>bBox)
		cordN0x1=cordN0x+0.02)
		when(((INST->cellName=="gate.INV.0-L1_1-R") && (INST->name=="L.e"))
		cordLx=caar(INST~>bBox)
		cordLx1=cordLx+0.04
		cordLx2=cordLx1+0.06)
		when(((INST->cellName=="stack.NMOS_CHAIN_5.0-L1-R") && (INST->name=="rv.N2"))
		cordrvx=caar(INST~>bBox)
		cordrvx2=caadr(INST~>bBox)
		cordrv1=cordrvx+0.005
		cordrv2=cordrv1-0.06)
		when((INST->cellName=="stack.PMOS_CHAIN_1.0-L1-R") && (INST->name=="rv.P1")
		cordrvPx=caar(INST~>bBox))
		when((INST->cellName=="gate.INV.0-L1_1-R") && (INST->name=="R.2")
		cordR2y2=cadadr(INST~>bBox)
		cordR2x1=caar(INST~>bBox)
		cordR2=caadr(INST~>bBox))
		when((INST->cellName=="gate.INV.0-L1_1-R") && (INST->name=="R.0")
		cordR0y1=cadar(INST~>bBox)
		cordR0x1=caar(INST~>bBox)
		cordR0=caadr(INST~>bBox))
		when((INST->cellName=="gate.INV.0-L1_1-R") && (INST->name=="R.3")
		cordR3y2=cadadr(INST~>bBox))
		when((INST->cellName=="gate.INV.0-L1_1-R") && (INST->name=="R.1")
		cordR1y1=cadar(INST~>bBox)
		cordR1y2=cadadr(INST~>bBox)
		cordRx1=caar(INST~>bBox))
		when((INST->cellName=="gate.INV.0-L1_1-R") && (INST->name=="L.e")
		cordLey2=cadadr(INST~>bBox)
		cordLe=caadr(INST~>bBox))
			)

	foreach(INST CellView->instances
		(let ( xy1 xy2 XY bx1 bx2 by1 by2 diff)
		xy1=car(INST~>xy)
		xy2=cadr(INST~>xy)
		bx1=caar(INST~>bBox)
		by1=cadar(INST~>bBox)
		bx2=caadr(INST~>bBox)
		by2=cadadr(INST~>bBox)
		when(((INST->name=="PD3") || (INST->name=="PU3") || (INST->name=="PD2") || (INST->name=="PU2") || (INST->name=="PD1") || (INST->name=="PU1") || (INST->name=="PD0") || (INST->name=="PU0"))
		XY=(cordx2+0.1:xy2)
		dbSet(INST XY "xy")) ; moves M1_poly vias
		when((INST->cellName=="gate.INV.0-L1_1-R") &&((INST->name=="R.3")||(INST->name=="R.1"))
		when(cordR1y2==11.4
		when((R3NWidth/3)>=0.46
		dbReplaceProp(INST "n_contact_offset" "float" 0.06))
		when((R3NWidth/3)<0.46
		dbReplaceProp(INST "n_contact_offset" "float" (0.76-0.04-(R3NWidth/3)-0.2))))
		when(cordR1y2==11.27
		when((R3NWidth/2)>=0.46
		dbReplaceProp(INST "n_contact_offset" "float" 0.06))
		when((R3NWidth/2)<0.46
		dbReplaceProp(INST "n_contact_offset" "float" (0.76-0.04-(R3NWidth/2)-0.2))))
		when(cordR1y2==11.14
		when(R3NWidth>=0.46
		dbReplaceProp(INST "n_contact_offset" "float" 0.06))
		when(R3NWidth<0.46
		dbReplaceProp(INST "n_contact_offset" "float" (0.76-0.04-R3NWidth-0.2))))
		ActualcordRx1=caar(INST~>bBox))
		when((INST->cellName=="gate.INV.0-L1_1-R") &&((INST->name=="R.2")||(INST->name=="R.0"))
		when(cordR2y2==9.84
		when((R2PWidth/3)>=0.27
		dbReplaceProp(INST "p_contact_offset" "float" 0.06))
		when((R2PWidth/3)<0.27
		dbReplaceProp(INST "p_contact_offset" "float" (1.29-0.76-(R2PWidth/3)-0.2))))
		when(cordR2y2==9.71
		when((R2PWidth/2)>=0.27
		dbReplaceProp(INST "p_contact_offset" "float" 0.06))
		when((R2PWidth/2)<0.27
		dbReplaceProp(INST "p_contact_offset" "float" (1.29-0.76-(R2PWidth/2)-0.2))))
		when(cordR2y2==9.58
		when(R2PWidth>=0.27
		dbReplaceProp(INST "p_contact_offset" "float" 0.06))
		when(R2PWidth<0.27
		dbReplaceProp(INST "p_contact_offset" "float" (1.29-0.76-R2PWidth-0.2))))
		ActualcordRx0=caadr(INST~>bBox))
		when((INST->cellName=="gate.INV.0-L1_1-R") && (INST->name=="Reset")
		when(ResPWidth>=0.27
		dbReplaceProp(INST "p_contact_offset" "float" 0.06))
		when(ResPWidth<0.27
		dbReplaceProp(INST "p_contact_offset" "float" (0.54-ResPWidth-0.2)))
		ActualReset=caadr(INST~>bBox))
		when(((INST->name=="ND3") || (INST->name=="NU3") || (INST->name=="ND2") || (INST->name=="NU2") || (INST->name=="ND1") || (INST->name=="NU1") || (INST->name=="ND0") || (INST->name=="NU0") || (INST->name=="R3") || (INST->name=="R2") || (INST->name=="R1") || (INST->name=="R0"))
			XY=(cordNx2-0.1:xy2)
			ActualPolyLeft=cordNx2-0.1
			dbSet(INST XY "xy")) ; moves M1_poly vias
		))

	foreach(INST CellView->instances
		(let ( xy1 xy2 XY bx1 bx2 by1 by2 diff)
		xy1=car(INST~>xy)
		xy2=cadr(INST~>xy)
		bx1=caar(INST~>bBox)
		by1=cadar(INST~>bBox)
		bx2=caadr(INST~>bBox)
		by2=cadadr(INST~>bBox)
		when((INST->cellName=="gate.INV.0-L1_1-R") && (INST->name=="_Reset")
		when(ResetNWidth<0.27
		dbReplaceProp(INST "n_contact_offset" "float" (0.76-0.22-ResetNWidth-0.2)))
		when(ResetNWidth>0.27
		dbReplaceProp(INST "n_contact_offset" "float" 0.06))
		ActualResx=caar(INST~>bBox))
		when((INST~>cellName=="M2_M1_2cut_p1_2")&&((xy1==0.505&&xy2==4.16)||(xy1==1.015&&xy2==4.16))
		when((cordLey2==3.99)||(cordLey2==3.86)||(cordLey2==4.12)
		dbDeleteObject(INST)))
		when((INST~>cellName=="M2_M1_2cut_p1_2")&&((xy1==0.505&&xy2==3.9)||(xy1==1.015&&xy2==3.9))
		when(cordLey2==3.86
		dbDeleteObject(INST)))
		when((INST~>cellName=="M2_M1_2cut_p1_2")&&((xy1==0.505&&xy2==11.18)||(xy1==1.015&&xy2==11.18))
		when(cordR3y2==11.14
		dbDeleteObject(INST)))
		when((INST~>cellName=="M2_M1_2cut_p1_2")&&((xy1==0.505&&xy2==9.62)||(xy1==1.015&&xy2==9.62))
		when(cordR2y2==9.58
		dbDeleteObject(INST)))
		when((INST~>cellName=="M2_M1_2cut_p1_2")&&((xy1==0.505&&xy2==2.73)||(xy1==1.015&&xy2==2.73))
		when(cordR1y1==2.77
		dbDeleteObject(INST)))
		when((INST~>cellName=="M2_M1_2cut_p1_2")&&((xy1==0.505&&xy2==1.3)||(xy1==1.015&&xy2==1.3))
		when(cordR0y1==1.34
		dbDeleteObject(INST)))
		))
;moving wires as per the new widths of instances
	foreach(SHAPE CellView->shapes
		(let (bx1 bx2 by1 by2 x1 x2 x3 x4 x5 x6 x7 x8 y1 y2 y3 y4 y5 y6 y7 y8 xy1 xy2 pnts bbox orgn)
		bx1=caar(SHAPE~>bBox)
		by1=cadar(SHAPE~>bBox)
		bx2=caadr(SHAPE~>bBox)
		by2=cadadr(SHAPE~>bBox)
		xy1=car(SHAPE~>xy)
		xy2=cadr(SHAPE~>xy)
		x1=caar(SHAPE~>points)
		y1=cadar(SHAPE~>points)
		x2=caadr(SHAPE~>points)
		y2=cadadr(SHAPE~>points)
		x3=caaddr(SHAPE~>points)
		y3=car(cdaddr(SHAPE~>points))
		x4=car(cadddr(SHAPE~>points))
		y4=cadr(cadddr(SHAPE~>points))
		x5=caar(cddddr(SHAPE~>points))
		y5=cadar(cddddr(SHAPE~>points))
		x6=caadr(cddddr(SHAPE~>points))
		y6=cadadr(cddddr(SHAPE~>points))
		x7=caaddr(cddddr(SHAPE~>points))
		y7=car(cdaddr(cddddr(SHAPE~>points)))
		x8=car(cadddr(cddddr(SHAPE~>points)))
		y8=cadr(cadddr(cddddr(SHAPE~>points)))
		when((SHAPE~>layerName=="CO")&&((bx1==0.94&&by1==1.8)||(bx1==1.05&&by1==1.8)||(bx1==0.94&&by1==2.06)||(bx1==1.05&&by1==2.06))
		dbDeleteObject(SHAPE)
		dbCreateRect(CellView "M1" list(0.91:by1-0.01 cordP1x1-0.07:by2+0.01))
		when((bx1==0.94&&by1==1.8)||(bx1==0.94&&by1==2.06)
		i = 0.94
		for(k 0 20
		dbCreateRect(CellView "CO" list(i:by1 i+0.04:by2))
		when((i+0.15)>(cordP1x1-0.07)
		k=20
		i = 0.94)
		when((i+0.15)<=(cordP1x1-0.07)
		k = k+1
		i = i + 0.11)))) ; draws CO's for r.1 C2 gates on PMOS side
		when((SHAPE~>layerName=="CO")&&((bx1==0.94&&by1==12.07)||(bx1==1.05&&by1==12.07)||(bx1==0.94&&by1==11.81)||(bx1==1.05&&by1==11.81))
		dbDeleteObject(SHAPE)
		dbCreateRect(CellView "M1" list(0.91:by1-0.01 cordx1-0.07:by2+0.01))
		when((bx1==0.94&&by1==12.07)||(bx1==0.94&&by1==11.81)
		i = 0.94
		for(k 0 20
		dbCreateRect(CellView "CO" list(i:by1 i+0.04:by2))
		when((i+0.15)>(cordP1x1-0.07)
		k=20
		i = 0.94)
		when((i+0.15)<=(cordP1x1-0.07)
		k = k+1
		i = i + 0.11)))); draws CO's for r.3 C2 gates on PMOS side
		when((SHAPE~>layerName=="CO")&&((bx1==0.94&&by1==10.38)||(bx1==1.05&&by1==10.38)||(bx1==0.94&&by1==10.64)||(bx1==1.05&&by1==10.64))
		dbDeleteObject(SHAPE)
		dbCreateRect(CellView "M1" list(0.91:by1-0.01 cordP2x1-0.2:by2+0.01))
		when((bx1==0.94&&by1==10.38)||(bx1==0.94&&by1==10.64)
		i = 0.94
		for(k 0 20
		dbCreateRect(CellView "CO" list(i:by1 i+0.04:by2))
		when((i+0.15)>(cordP2x1-0.23)
		k=20
		i = 0.94)
		when((i+0.15)<=(cordP2x1-0.23)
		k = k+1
		i = i + 0.11)))); draws CO's for r.2 C2 gates on PMOS side
		when((SHAPE~>layerName=="CO")&&((bx1==0.94&&by1==0.37)||(bx1==1.05&&by1==0.37)||(bx1==0.94&&by1==0.63)||(bx1==1.05&&by1==0.63))
		dbDeleteObject(SHAPE)
		dbCreateRect(CellView "M1" list(0.91:by1-0.01 cordP0x1-0.2:by2+0.01))
		when((bx1==0.94&&by1==0.37)||(bx1==0.94&&by1==0.63)
		i = 0.94
		for(k 0 20
		dbCreateRect(CellView "CO" list(i:by1 i+0.04:by2))
		when((i+0.15)>(cordP0x1-0.23)
		k=20
		i = 0.94)
		when((i+0.15)<=(cordP0x1-0.23)
		k = k+1
		i = i + 0.11)))); draws CO's for r.0 C2 gates on PMOS side
		when((SHAPE~>layerName=="CO")&&((bx1==0.53&&by1==12.07)||(bx1==0.53&&by1==11.81))
		dbDeleteObject(SHAPE)
		dbCreateRect(CellView "M1" list(0.61:by1-0.01 cordNx1+0.07:by2+0.01))
		i = 0.57
		for(k 0 20
		dbCreateRect(CellView "CO" list(i:by1 i-0.04:by2))
		when((i-0.15)<(cordNx1+0.07)
		k=20
		i = 0.57)
		when((i-0.15)>=(cordNx1+0.07)
		k = k+1
		i = i - 0.11))) ; draws CO's for r.3 C2 gates on NMOS side
		when((SHAPE~>layerName=="CO")&&((bx1==0.53&&by1==10.64)||(bx1==0.53&&by1==10.38))
		dbDeleteObject(SHAPE)
		dbCreateRect(CellView "M1" list(0.61:by1-0.01 cordN2x1+0.07:by2+0.01))
		i = 0.57
		for(k 0 20
		dbCreateRect(CellView "CO" list(i:by1 i-0.04:by2))
		when((i-0.15)<(cordN2x1+0.07)
		k=20
		i = 0.57)
		when((i-0.15)>=(cordN2x1+0.07)
		k = k+1
		i = i - 0.11))) ; draws CO's for r.2 C2 gates on NMOS side
		when((SHAPE~>layerName=="CO")&&((bx1==0.525&&by1==2.06)||(bx1==0.525&&by1==1.8))
		dbDeleteObject(SHAPE)
		dbCreateRect(CellView "M1" list(0.61:by1-0.01 cordN1x1+0.07:by2+0.01))
		i = 0.57
		for(k 0 20
		dbCreateRect(CellView "CO" list(i:by1 i-0.04:by2))
		when((i-0.15)<(cordN1x1+0.07)
		k=20
		i = 0.57)
		when((i-0.15)>=(cordN1x1+0.07)
		k = k+1
		i = i - 0.11))) ; draws CO's for r.1 C2 gates on NMOS side
		when((SHAPE~>layerName=="CO")&&((bx1==0.525&&by1==0.63)||(bx1==0.525&&by1==0.37))
		dbDeleteObject(SHAPE)
		dbCreateRect(CellView "M1" list(0.61:by1-0.01 cordN0x1+0.07:by2+0.01))
		i = 0.57
		for(k 0 20
		dbCreateRect(CellView "CO" list(i:by1 i-0.04:by2))
		when((i-0.15)<(cordN0x1+0.07)
		k=20
		i = 0.57)
		when((i-0.15)>=(cordN0x1+0.07)
		k = k+1
		i = i - 0.11))) ; draws CO's for r.0 C2 gates on NMOS side
		when( (SHAPE~>net~>name=="PU.3") || (SHAPE~>net~>name=="PU.2") || (SHAPE~>net~>name=="PD.1") || (SHAPE~>net~>name=="PD.0")
		pnts=list(cordx2:y1 x2:y2 x3:y3 cordx1:y4 cordx1:y5 x6:y6 x7:y7 cordx2:y8)
		dbSet(SHAPE pnts "points")) ;moves M1 nets on the NMOS side of Van Berkel gate
		when((SHAPE~>net~>name=="R.e") && ((SHAPE~>layerName=="M1") || (SHAPE~>layerName=="M2") || (SHAPE~>layerName=="M3")|| (SHAPE~>layerName=="PO"))
		when(SHAPE~>layerName=="M1"
		bbox=list(cordx1+0.13:by1 cordx1+0.19:by2)
		dbSet(SHAPE bbox "bBox")) ; Moves R.e M1 wires
		when(SHAPE~>layerName=="M2"
		bbox=list(cordx2+0.115:by1 cordx2+0.115:by2)
		dbSet(SHAPE bbox "points")) ; moves R.e M2 wires
		when(SHAPE~>layerName=="M3"
		when((ActualcordRx0>=cordx2+0.17)
		bbox=list(bx1:by1 ActualcordRx0:by2))
		when((ActualcordRx0<cordx2+0.17)
		bbox=list(bx1:by1 (cordx2+0.17):by2))
		dbSet(SHAPE bbox "bBox")) ; moves R.e M2 wires
		when(SHAPE~>layerName=="PO"
		bbox=list(bx1:by1 cordx2+0.115:by2)
		dbSet(SHAPE bbox "bBox")) ; Moves R.e Poly wires

		)

		when((((SHAPE~>net~>name=="_r.2") || (SHAPE~>net~>name=="_r.2fix") || (SHAPE~>net~>name=="_r.1") || (SHAPE~>net~>name=="rv") || (SHAPE~>net~>name=="_r.3poly") || (SHAPE~>net~>name=="_r.2mov") || (SHAPE~>net~>name=="_r.0") || (SHAPE~>net~>name=="_r.3") || (SHAPE~>net~>name=="_Reset") || (SHAPE~>net~>name=="Reset") || (SHAPE~>net~>name=="_Resetfix") || (SHAPE~>net~>name=="_r.0fix") || (SHAPE~>net~>name=="_r.0mov") || (SHAPE~>net~>name=="_r.1mov")) && ((SHAPE~>layerName=="M1") || (SHAPE~>layerName=="M2") || (SHAPE~>layerName=="CO") || (SHAPE~>layerName=="PO")))
		when((SHAPE~>layerName=="CO") && (SHAPE~>net~>name=="_Reset")
		bbox=list((cordx2+0.08):by1 (cordx2+0.12):by2)
		dbSet(SHAPE bbox "bBox"))
		when((SHAPE~>layerName=="PO") && (SHAPE~>net~>name=="_Reset")
		bbox=list(bx1:by1 (cordx2+0.17):by2)
		dbSet(SHAPE bbox "bBox"))
		when((SHAPE~>layerName=="CO") && (SHAPE~>net~>name=="_r.2")
		bbox=list((cordx2-0.04):by1 cordx2:by2)
		dbSet(SHAPE bbox "bBox"))
		when((SHAPE~>layerName=="CO") && (SHAPE~>net~>name=="_r.1")
		when((cordrv1-0.01<=0.33)
		bbox=list((cordrv1-0.05):by1 (cordrv1-0.01):by2))
		when((cordrv1-0.01>0.33)
		bbox=list(0.29:by1 0.33:by2))
		dbSet(SHAPE bbox "bBox"))
		when((SHAPE~>layerName=="CO") && (SHAPE~>net~>name=="_r.3")
		when((cordrv1-0.01<=0.33)
		bbox=list((cordrv1-0.18):by1 (cordrv1-0.14):by2))
		when((cordrv1-0.01>0.33)
		bbox=list(0.16:by1 0.2:by2))
		dbSet(SHAPE bbox "bBox"))
		when((SHAPE~>layerName=="PO") && (SHAPE~>net~>name=="_r.2")
		bbox=list(bx1:by1 (cordx2+0.055):by2)
		dbSet(SHAPE bbox "bBox"))
		when((SHAPE~>layerName=="PO") && (SHAPE~>net~>name=="_r.1")
		when((cordrv1-0.01<=0.33)
		bbox=list((cordrv1-0.1):by1 bx2:by2))
		when((cordrv1-0.01>0.33)
		bbox=list(0.24:by1 bx2:by2))
		dbSet(SHAPE bbox "bBox"))
		when((SHAPE~>layerName=="PO") && (SHAPE~>net~>name=="_r.3")
		when((cordrv1-0.01<=0.33)
		bbox=list((cordrv1-0.23):by1 bx2:by2))
		when((cordrv1-0.01>0.33)
		bbox=list(0.11:by1 bx2:by2))
		ActualrvLeft=caar(bbox)
		dbSet(SHAPE bbox "bBox"))
		when((SHAPE~>layerName=="CO") && (SHAPE~>net~>name=="_r.0")
		bbox=list((cordx2-0.16):by1 (cordx2-0.12):by2)
		dbSet(SHAPE bbox "bBox"))
		when((SHAPE~>layerName=="PO") && (SHAPE~>net~>name=="_r.0")
		bbox=list(bx1:by1 (cordx2-0.065):by2)
		dbSet(SHAPE bbox "bBox"))
		when((SHAPE~>layerName=="M2") && (SHAPE~>net~>name=="_r.2")
		bbox=list((cordx2-0.145):by1 (cordx2-0.145):by2)
		dbSet(SHAPE bbox "points"))
		when((SHAPE~>layerName=="M2") && (SHAPE~>net~>name=="_Reset")
		bbox=list((cordx2-0.015):by1 (cordx2-0.015):by2)
		dbSet(SHAPE bbox "points"))
		when((SHAPE~>layerName=="M1") && (SHAPE~>net~>name=="rv")
		pnts=list(x1:y1 cordLx1:y2 cordLx1:y3 cordLx2:y4 cordLx2:y5 x6:y6)
		dbSet(SHAPE pnts "points"))
		when((SHAPE~>layerName=="M2") && (SHAPE~>net~>name=="_r.0")
		bbox=list((cordx2-0.145):by1 (cordx2-0.145):by2)
		dbSet(SHAPE bbox "points"))
		when((SHAPE~>layerName=="M1") && ((SHAPE~>net~>name=="_r.0")||(SHAPE~>net~>name=="_r.2"))
		bbox=list(bx1:by1 (cordx2-0.145):by2)
		dbSet(SHAPE bbox "bBox"))
		when((SHAPE~>layerName=="M1") && (SHAPE~>net~>name=="_Resetfix")
		pnts=list((cordx2+0.155):y1 (cordx2+0.13):y2 (cordx2+0.13):y3 (cordx2+0.07):y4 (cordx2+0.07):y5 (cordx2-0.015):y6 (cordx2-0.015):y7 (cordx2+0.155):y8)
		dbSet(SHAPE pnts "points"))
		when((SHAPE~>layerName=="M1") && (SHAPE~>net~>name=="_r.2fix")
		pnts=list((cordx2+0.02):y1 (cordx2-0.145):y2 (cordx2-0.145):y3 (cordx2-0.05):y4 (cordx2-0.05):y5 (cordx2+0.01):y6 (cordx2+0.01):y7 (cordx2+0.02):y8)
		dbSet(SHAPE pnts "points"))
		when((SHAPE~>layerName=="M1") && (SHAPE~>net~>name=="_r.0fix")
		pnts=list((cordx2-0.09):y1 (cordx2-0.11):y2 (cordx2-0.11):y3 (cordx2-0.17):y4 (cordx2-0.17):y5 (cordx2-0.2):y6 (cordx2-0.2):y7 (cordx2-0.09):y8)
		dbSet(SHAPE pnts "points"))
		when((SHAPE~>layerName=="M1") && (SHAPE~>net~>name=="_Reset")
		pnts=list(x1:y1 (cordx2-0.015):y2 (cordx2-0.015):y3)
		dbSet(SHAPE pnts "points"))
		when((SHAPE~>layerName=="M1") && (SHAPE~>net~>name=="_r.2mov")
		when((ActualcordRx0-0.11)>=(cordx2-0.145)
		pnts=list((ActualcordRx0-0.04):y1 (cordx2-0.145):y2 (cordx2-0.145):y3 (ActualcordRx0-0.11):y4 (ActualcordRx0-0.11):y5 (cordx2-0.145):y6 (cordx2-0.145):y7 (ActualcordRx0-0.04):y8))
		when((ActualcordRx0-0.11)<(cordx2-0.145)
		pnts=list((ActualcordRx0-0.11):y1 (cordx2-0.145):y2 (cordx2-0.145):y3 (ActualcordRx0-0.04):y4 (ActualcordRx0-0.04):y5 (cordx2-0.145):y6 (cordx2-0.145):y7 (ActualcordRx0-0.11):y8))
		dbSet(SHAPE pnts "points"))
		when((SHAPE~>layerName=="M1") && (SHAPE~>net~>name=="_r.1")
		when((cordrv1-0.01<=0.33)
		pnts=list(x1:y1 cordrv1:y2 cordrv1:y3 cordrv2:y4 cordrv2:y5 cordrv1:y6 cordrv1:y7 x8:y8))
		when((cordrv1-0.01>0.33)
		pnts=list(x1:y1 0.34:y2 0.34:y3 0.28:y4 0.28:y5 0.34:y6 0.34:y7 x8:y8))
		dbSet(SHAPE pnts "points"))
		when((SHAPE~>layerName=="M1") && (SHAPE~>net~>name=="_r.3poly")
		when((cordrv1-0.01<=0.33)
		pnts=list(x1:y1 (cordrv2-0.07):y2 (cordrv2-0.07):y3 (cordrv2-0.13):y4 (cordrv2-0.13):y5 (cordrv2-0.07):y6 (cordrv2-0.07):y7 x8:y8))
		when((cordrv1-0.01>0.33)
		pnts=list(x1:y1 0.21:y2 0.21:y3 0.15:y4 0.15:y5 0.21:y6 0.21:y7 x8:y8))
		dbSet(SHAPE pnts "points"))
		when((SHAPE~>layerName=="M1") && (SHAPE~>net~>name=="_r.0mov")
		when((ActualcordRx0-0.11)>=(cordx2-0.145)
		pnts=list(ActualcordRx0-0.05:y1 (ActualcordRx0-0.11):y2 (ActualcordRx0-0.11):y3 (cordx2-0.145):y4 (cordx2-0.145):y5 (ActualcordRx0-0.05):y6 ))
		when((ActualcordRx0-0.11)<(cordx2-0.145)
		pnts=list(ActualcordRx0-0.05:y1 (ActualcordRx0-0.11):y2 (ActualcordRx0-0.11):y5 (cordx2-0.145):y6 (cordx2-0.145):y4 (ActualcordRx0-0.05):y3 ))
		dbSet(SHAPE pnts "points"))
		when((SHAPE~>layerName=="M1") && (SHAPE~>net~>name=="_r.1mov")
		pnts=list(x1:y1 (ActualcordRx1+0.04):y2 (ActualcordRx1+0.04):y3 (ActualcordRx1+0.1):y4 (ActualcordRx1+0.1):y5 x6:y6)
		dbSet(SHAPE pnts "points"))
		when((SHAPE~>layerName=="M1") && (SHAPE~>net~>name=="Reset")
		pnts=list(x1:y1 (ActualResx+0.03):y2 (ActualResx+0.03):y3 (ActualResx+0.09):y4 (ActualResx+0.09):y5 x6:y6)
		dbSet(SHAPE pnts "points"))
		)
		when((SHAPE~>net~>name=="_RESET") && (SHAPE~>layerName=="M1")
		when(cordLey2==4.51
		when((LePWidth/6)>=0.27
		pnts=list(x1:y1 (cordLe+0.02):y2 (cordLe+0.02):y3 ActualReset-0.07:y4))
		when((LePWidth/6)<0.27
		pnts=list(x1:y1 1.21:y2 1.21:y3 ActualReset-0.07:y4)))
		when(cordLey2==4.38
		when((LePWidth/5)>=0.27
		pnts=list(x1:y1 (cordLe+0.02):y2 (cordLe+0.02):y3 ActualReset-0.07:y4))
		when((LePWidth/5)<0.27
		pnts=list(x1:y1 1.21:y2 1.21:y3 ActualReset-0.07:y4)))
		when(cordLey2==4.25
		when((LePWidth/4)>=0.27
		pnts=list(x1:y1 (cordLe+0.02):y2 (cordLe+0.02):y3 ActualReset-0.07:y4))
		when((LePWidth/4)<0.27
		pnts=list(x1:y1 1.21:y2 1.21:y3 ActualReset-0.07:y4)))
		when(cordLey2==4.12
		when((LePWidth/3)>=0.27
		pnts=list(x1:y1 (cordLe+0.02):y2 (cordLe+0.02):y3 ActualReset-0.07:y4))
		when((LePWidth/3)<0.27
		pnts=list(x1:y1 1.21:y2 1.21:y3 ActualReset-0.07:y4)))
		when(cordLey2==3.99
		when((LePWidth/2)>=0.27
		pnts=list(x1:y1 (cordLe+0.02):y2 (cordLe+0.02):y3 ActualReset-0.07:y4))
		when((LePWidth/2)<0.27
		pnts=list(x1:y1 1.21:y2 1.21:y3 ActualReset-0.07:y4)))
		when(cordLey2==3.86
		when(LePWidth>=0.27
		pnts=list(x1:y1 (cordLe+0.02):y2 (cordLe+0.02):y3 ActualReset-0.07:y4))
		when(LePWidth<0.27
		pnts=list(x1:y1 1.21:y2 1.21:y3 ActualReset-0.07:y4)))
		dbSet(SHAPE pnts "points"))
		when(SHAPE~>net~>name=="NU.3"
		pnts=list(x1:y1 cordNx2:y2 cordNx2:y3 x4:y4 x5:y5 cordNx1:y6 cordNx1:y7 x8:y8)
		dbSet(SHAPE pnts "points"))
		when(SHAPE~>net~>name=="NU.2"
		pnts=list(x1:y1 cordNx1-0.03:y2 cordNx1-0.03:y3 x4:y4 )
		dbSet(SHAPE pnts "points"))
		when(SHAPE~>net~>name=="ND.1"
		pnts=list(x1:y1 cordNx1:y2 cordNx1:y3 x4:y4 x5:y5 cordNx2:y6 cordNx2:y7 x8:y8)
		dbSet(SHAPE pnts "points"))
		when(SHAPE~>net~>name=="ND.0"
		pnts=list(x1:y1 cordNx1-0.03:y2 cordNx1-0.03:y3 x4:y4)
		dbSet(SHAPE pnts "points")) ;moves M1 nets on the PMOS side of the Van Berkel gate
		when((SHAPE~>layerName=="M3") && SHAPE~>net~>name=="_RESET"
		when(ActualcordRx1>=(cordNx2-0.03)
		Actualcordr3x=cordNx2+0.015
		when((ActualcordRx1<=cordNx2-0.17)&&(ActualcordRx0>=cordx2+0.17)&&(Actualcordr3x-0.055>=ActualcordRx1)
		bbox=list(ActualcordRx1:by1 ActualcordRx0:by2))
		when((ActualcordRx1<=cordNx2-0.17)&&(ActualcordRx0>=cordx2+0.17)&&(Actualcordr3x-0.055<ActualcordRx1)
		bbox=list(Actualcordr3x-0.055:by1 ActualcordRx0:by2))
		when((ActualcordRx1<=cordNx2-0.17)&&(ActualcordRx0<cordx2+0.17)&&(Actualcordr3x-0.055>=ActualcordRx1)
		bbox=list(ActualcordRx1:by1 (cordx2+0.17):by2))
		when((ActualcordRx1<=cordNx2-0.17)&&(ActualcordRx0<cordx2+0.17)&&(Actualcordr3x-0.055<ActualcordRx1)
		bbox=list(Actualcordr3x-0.055:by1 (cordx2+0.17):by2))
		when((ActualcordRx1>cordNx2-0.17)&&(ActualcordRx0>=cordx2+0.17)&&(Actualcordr3x-0.055>=ActualcordRx1)
		bbox=list(cordNx2-0.17:by1 ActualcordRx0:by2))
		when((ActualcordRx1>cordNx2-0.17)&&(ActualcordRx0>=cordx2+0.17)&&(Actualcordr3x-0.055<ActualcordRx1)
		bbox=list(Actualcordr3x-0.055:by1 ActualcordRx0:by2))
		when((ActualcordRx1>cordNx2-0.17)&&(ActualcordRx0<cordx2+0.17)&&(Actualcordr3x-0.055>=ActualcordRx1)
		bbox=list(cordNx2-0.17:by1 (cordx2+0.17):by2))
		when((ActualcordRx1>cordNx2-0.17)&&(ActualcordRx0<cordx2+0.17)&&(Actualcordr3x-0.055<ActualcordRx1)
		bbox=list(Actualcordr3x-0.055:by1 (cordx2+0.17):by2)))
		when(ActualcordRx1<(cordNx2-0.03)
		Actualcordr3x=cordNx2-0.245
		when((ActualcordRx1<=cordNx2-0.17)&&(ActualcordRx0>=cordx2+0.17)&&(Actualcordr3x-0.055>=ActualcordRx1)
		bbox=list(ActualcordRx1:by1 ActualcordRx0:by2))
		when((ActualcordRx1<=cordNx2-0.17)&&(ActualcordRx0>=cordx2+0.17)&&(Actualcordr3x-0.055<ActualcordRx1)
		bbox=list(Actualcordr3x-0.055:by1 ActualcordRx0:by2))
		when((ActualcordRx1<=cordNx2-0.17)&&(ActualcordRx0<cordx2+0.17)&&(Actualcordr3x-0.055>=ActualcordRx1)
		bbox=list(ActualcordRx1:by1 (cordx2+0.17):by2))
		when((ActualcordRx1<=cordNx2-0.17)&&(ActualcordRx0<cordx2+0.17)&&(Actualcordr3x-0.055<ActualcordRx1)
		bbox=list(Actualcordr3x-0.055:by1 (cordx2+0.17):by2))
		when((ActualcordRx1>cordNx2-0.17)&&(ActualcordRx0>=cordx2+0.17)&&(Actualcordr3x-0.055>=ActualcordRx1)
		bbox=list(cordNx2-0.17:by1 ActualcordRx0:by2))
		when((ActualcordRx1>cordNx2-0.17)&&(ActualcordRx0>=cordx2+0.17)&&(Actualcordr3x-0.055<ActualcordRx1)
		bbox=list(Actualcordr3x-0.055:by1 ActualcordRx0:by2))
		when((ActualcordRx1>cordNx2-0.17)&&(ActualcordRx0<cordx2+0.17)&&(Actualcordr3x-0.055>=ActualcordRx1)
		bbox=list(cordNx2-0.17:by1 (cordx2+0.17):by2))
		when((ActualcordRx1>cordNx2-0.17)&&(ActualcordRx0<cordx2+0.17)&&(Actualcordr3x-0.055<ActualcordRx1)
		bbox=list(Actualcordr3x-0.055:by1 (cordx2+0.17):by2)))
		dbSet(SHAPE bbox "bBox"))

		when((SHAPE~>layerName=="M3") && SHAPE~>net~>name=="L.e"
		when((cordrv1-0.01<=0.33)
		bbox=list((cordrv1-0.23):by1 bx2:by2))
		when((cordrv1-0.01>0.33)
		bbox=list(0.11:by1 bx2:by2))
		ActualrvLeft=caar(bbox)
		when(ActualcordRx1>=(cordNx2-0.03)&&(ActualcordRx1<=ActualrvLeft)
		Actualcordr3x=cordNx2+0.015
		when((ActualcordRx1<=cordNx2-0.17)&&(Actualcordr3x-0.055>=ActualcordRx1)
		bbox=list(ActualcordRx1:by1 bx2:by2))
		when((ActualcordRx1<=cordNx2-0.17)&&(Actualcordr3x-0.055<ActualcordRx1)
		bbox=list(Actualcordr3x-0.055:by1 bx2:by2))
		when((ActualcordRx1>cordNx2-0.17)&&(Actualcordr3x-0.055>=ActualcordRx1)
		bbox=list(cordNx2-0.17:by1 bx2:by2))
		when((ActualcordRx1>cordNx2-0.17)&&(Actualcordr3x-0.055<ActualcordRx1)
		bbox=list(Actualcordr3x-0.055:by1 bx2:by2)))
		when(ActualcordRx1<(cordNx2-0.03)&&(cordNx2-0.03<=ActualrvLeft)
		Actualcordr3x=cordNx2-0.245
		when((ActualcordRx1<=cordNx2-0.17)&&(Actualcordr3x-0.055>=ActualcordRx1)
		bbox=list(ActualcordRx1:by1 bx2:by2))
		when((ActualcordRx1<=cordNx2-0.17)&&(Actualcordr3x-0.055<ActualcordRx1)
		bbox=list(Actualcordr3x-0.055:by1 bx2:by2))
		when((ActualcordRx1>cordNx2-0.17)&&(Actualcordr3x-0.055>=ActualcordRx1)
		bbox=list(cordNx2-0.17:by1 bx2:by2))
		when((ActualcordRx1>cordNx2-0.17)&&(Actualcordr3x-0.055<ActualcordRx1)
		bbox=list(Actualcordr3x-0.055:by1 bx2:by2)))
		when(ActualrvLeft<(cordNx2-0.03)&&(ActualrvLeft<ActualcordRx1)
		when((ActualcordRx0>=cordx2+0.17)
		bbox=list(ActualrvLeft:by1 bx2:by2))
		when((ActualcordRx0<cordx2+0.17)
		bbox=list(ActualrvLeft:by1 bx2:by2))
		)
		dbSet(SHAPE bbox "bBox"))
		when(((SHAPE~>net~>name=="L.3") || (SHAPE~>net~>name=="L.2") || (SHAPE~>net~>name=="L.1") || (SHAPE~>net~>name=="L.0")|| (SHAPE~>net~>name=="R.3")  || (SHAPE~>net~>name=="R.2") || (SHAPE~>net~>name=="R.1") || (SHAPE~>net~>name=="R.0")) && ((SHAPE~>layerName=="M1") || (SHAPE~>layerName=="M2") || (SHAPE~>layerName=="M3")|| (SHAPE~>layerName=="PO"))
		when((SHAPE~>layerName=="M1") && ((SHAPE~>net~>name=="L.3") || (SHAPE~>net~>name=="L.2") || (SHAPE~>net~>name=="L.1") || (SHAPE~>net~>name=="L.0"))
		bbox=list(cordNx1-0.13:by1 cordNx1-0.19:by2)
		dbSet(SHAPE bbox "bBox")) ; Moves R.e M1 wires
		when((SHAPE~>layerName=="M1") && (SHAPE~>net~>name=="R.3")
		when((cordRx1+0.505)>=(cordNx2+0.13)
		pnts=list(x1:y1 (cordNx1-0.12):y2 (cordNx1-0.12):y3 (cordNx1-0.18):y4 (cordNx1-0.18):y5 x6:y6 x7:y7 x8:y8))
		when((cordRx1+0.505)<(cordNx2+0.13)
		pnts=list(x1:y1 (cordNx1-0.12):y2 (cordNx1-0.12):y3 (cordNx1-0.18):y4 (cordNx1-0.18):y5 x6:y6 x7:y7 x8:y8))
		dbSet(SHAPE pnts "points")) ; Moves R.e M1 wires
		when((SHAPE~>layerName=="M1") && (SHAPE~>net~>name=="R.1")
		pnts=list(x1:y1 x2:y2 x3:y3 (cordNx1-0.18):y4 (cordNx1-0.18):y5 (cordNx1-0.12):y6 (cordNx1-0.12):y7 x8:y8)
		dbSet(SHAPE pnts "points")) ; Moves R.e M1 wires
		when((SHAPE~>layerName=="M1") && (SHAPE~>net~>name=="R.2")
		when((cordNx1-0.12)<=cordR2x1-0.01
		pnts=list(x1:y1 (cordNx1-0.12):y2 (cordNx1-0.12):y3 (cordNx1-0.17):y4))
		when((cordNx1-0.12)>cordR2x1-0.01
		pnts=list(x1:y1 (cordR2x1-0.01):y2 (cordR2x1-0.01):y3 ActualPolyLeft:y4))
		dbSet(SHAPE pnts "points")) ; Moves R.e M1 wires
		when((SHAPE~>layerName=="M1") && (SHAPE~>net~>name=="R.0")
		when((cordNx1-0.12)<=cordR0x1-0.01
		pnts=list(x1:y1 (cordNx1-0.12):y2 (cordNx1-0.12):y3 (cordNx1-0.17):y4))
		when((cordNx1-0.12)>cordR0x1-0.01
		pnts=list(x1:y1 (cordR0x1-0.01):y2 (cordR0x1-0.01):y3 ActualPolyLeft:y4))
		dbSet(SHAPE pnts "points")) ; Moves R.e M1 wires
		when((SHAPE~>layerName=="M3") && ((SHAPE~>net~>name=="L.3") || (SHAPE~>net~>name=="L.2") || (SHAPE~>net~>name=="L.1") || (SHAPE~>net~>name=="L.0"))
		when((cordrv1-0.01<=0.33)
		bbox=list((cordrv1-0.23):by1 bx2:by2))
		when((cordrv1-0.01>0.33)
		bbox=list(0.11:by1 bx2:by2))
		ActualrvLeft=caar(bbox)
		when(ActualcordRx1>=(cordNx2-0.03)&&(ActualcordRx1<=ActualrvLeft)
		Actualcordr3x=cordNx2+0.015
		when((ActualcordRx1<=cordNx2-0.17)&&(Actualcordr3x-0.055>=ActualcordRx1)
		bbox=list(ActualcordRx1:by1 bx2:by2))
		when((ActualcordRx1<=cordNx2-0.17)&&(Actualcordr3x-0.055<ActualcordRx1)
		bbox=list(Actualcordr3x-0.055:by1 bx2:by2))
		when((ActualcordRx1>cordNx2-0.17)&&(Actualcordr3x-0.055>=ActualcordRx1)
		bbox=list(cordNx2-0.17:by1 bx2:by2))
		when((ActualcordRx1>cordNx2-0.17)&&(Actualcordr3x-0.055<ActualcordRx1)
		bbox=list(Actualcordr3x-0.055:by1 bx2:by2)))
		when(ActualcordRx1<(cordNx2-0.03)&&(cordNx2-0.03<=ActualrvLeft)
		Actualcordr3x=cordNx2-0.245
		when((ActualcordRx1<=cordNx2-0.17)&&(Actualcordr3x-0.055>=ActualcordRx1)
		bbox=list(ActualcordRx1:by1 bx2:by2))
		when((ActualcordRx1<=cordNx2-0.17)&&(Actualcordr3x-0.055<ActualcordRx1)
		bbox=list(Actualcordr3x-0.055:by1 bx2:by2))
		when((ActualcordRx1>cordNx2-0.17)&&(Actualcordr3x-0.055>=ActualcordRx1)
		bbox=list(cordNx2-0.17:by1 bx2:by2))
		when((ActualcordRx1>cordNx2-0.17)&&(Actualcordr3x-0.055<ActualcordRx1)
		bbox=list(Actualcordr3x-0.055:by1 bx2:by2)))
		when(ActualrvLeft<(cordNx2-0.03)&&(ActualrvLeft<ActualcordRx1)
		when((ActualcordRx0>=cordx2+0.17)
		bbox=list(ActualrvLeft:by1 bx2:by2))
		when((ActualcordRx0<cordx2+0.17)
		bbox=list(ActualrvLeft:by1 bx2:by2))
		)
		dbSet(SHAPE bbox "bBox")) ; moves R.e M2 wires
		when((SHAPE~>layerName=="M3") && ((SHAPE~>net~>name=="R.3") || (SHAPE~>net~>name=="R.2") || (SHAPE~>net~>name=="R.1") || (SHAPE~>net~>name=="R.0"))
		when((ActualcordRx0>=cordx2+0.17)
		bbox=list(bx1:by1 ActualcordRx0:by2))
		when((ActualcordRx0<cordx2+0.17)
		bbox=list(bx1:by1 (cordx2+0.17):by2))
		dbSet(SHAPE bbox "bBox")) ; moves R.e M2 wires
		when((SHAPE~>layerName=="M2") && ((SHAPE~>net~>name=="L.3") || (SHAPE~>net~>name=="L.2") || (SHAPE~>net~>name=="L.1") || (SHAPE~>net~>name=="L.0"))
		bbox=list(cordNx2-0.115:by1 cordNx2-0.115:by2)
		dbSet(SHAPE bbox "points")) ; moves R.e M2 wires
		when(SHAPE~>layerName=="PO"
		bbox=list(cordNx2-0.115:by1 bx2:by2)
		dbSet(SHAPE bbox "bBox")) ; Moves R.e Poly wires
		)
		when(((SHAPE~>net~>name=="_r.3") || (SHAPE~>net~>name=="_r.3mov"))&&((SHAPE~>layerName=="M1") || (SHAPE~>layerName=="M2"))
		when(SHAPE~>layerName=="M2"
		when(ActualcordRx1>=(cordNx2-0.03)
		bbox=list((cordNx2+0.015):by1 (cordNx2+0.015):by2))
		when(ActualcordRx1<(cordNx2-0.03)
		bbox=list((cordNx2-0.245):by1 (cordNx2-0.245):by2))
		dbSet(SHAPE bbox "points"))
		when((SHAPE~>layerName=="M1") && (SHAPE~>net~>name=="_r.3")
		when(ActualcordRx1>=(cordNx2-0.03)
		pnts=list(x1:y1 (cordNx2+0.015):y2 (cordNx2+0.015):y3 x4:y4 x5:y5 x6:y6))
		when(ActualcordRx1<(cordNx2-0.03)
		pnts=list(x1:y1 (cordNx2-0.245):y2 (cordNx2-0.245):y3 x4:y4 x5:y5 x6:y6))
		dbSet(SHAPE pnts "points"))
		when((SHAPE~>layerName=="M1") && (SHAPE~>net~>name=="_r.3mov")
		when(ActualcordRx1>=(cordNx2-0.03)
		bbox=list(ActualcordRx1+0.03:by1 (cordNx2+0.015):by2))
		when(ActualcordRx1<(cordNx2-0.03)
		bbox=list(ActualcordRx1+0.03:by1 (cordNx2-0.245):by2))
		dbSet(SHAPE bbox "bBox"))) ; moves R.e M2 wires
		when((SHAPE~>layerName=="prBoundary")
		when((cordrv1-0.01<=0.33)
		bbox=list((cordrv1-0.23):by1 bx2:by2))
		when((cordrv1-0.01>0.33)
		bbox=list(0.11:by1 bx2:by2))
		ActualrvLeft=caar(bbox)
		dbDeleteObject(SHAPE))
		when((SHAPE~>layerName=="M3")&&((bx1==0&&by1==12.385)||(bx1==0&&by1==10.945)||(bx1==0&&by1==10.825)||(bx1==0&&by1==9.385)||(bx1==0&&by1==9.265)||(bx1==0&&by1==7.825)||(bx1==0&&by1==7.705)||(bx1==0&&by1==6.265)||(bx1==0&&by1==6.145)||(bx1==0&&by1==4.705)||(bx1==0&&by1==4.585)||(bx1==0&&by1==3.145)||(bx1==0&&by1==3.025)||(bx1==0&&by1==1.585)||(bx1==0&&by1==1.465)||(bx1==0&&by1==0.025))
		when((cordrv1-0.01<=0.33)
		bbox=list((cordrv1-0.23):by1 bx2:by2))
		when((cordrv1-0.01>0.33)
		bbox=list(0.11:by1 bx2:by2))
		ActualrvLeft=caar(bbox)
		when(ActualcordRx1>=(cordNx2-0.03)
		Actualcordr3x=cordNx2+0.015
		when((ActualcordRx1<=cordNx2-0.17)&&(ActualcordRx0>=cordx2+0.17)&&(Actualcordr3x-0.055>=ActualcordRx1)
		bbox=list(ActualcordRx1-0.04:by1 (ActualcordRx0+0.04):by2))
		when((ActualcordRx1<=cordNx2-0.17)&&(ActualcordRx0>=cordx2+0.17)&&(Actualcordr3x-0.055<ActualcordRx1)
		bbox=list(Actualcordr3x-0.095:by1 (ActualcordRx0+0.04):by2))
		when((ActualcordRx1<=cordNx2-0.17)&&(ActualcordRx0<cordx2+0.17)&&(Actualcordr3x-0.055>=ActualcordRx1)
		bbox=list(ActualcordRx1-0.04:by1 (cordx2+0.21):by2))
		when((ActualcordRx1<=cordNx2-0.17)&&(ActualcordRx0<cordx2+0.17)&&(Actualcordr3x-0.055<ActualcordRx1)
		bbox=list(Actualcordr3x-0.095:by1 (cordx2+0.21):by2))
		when((ActualcordRx1>cordNx2-0.17)&&(ActualcordRx0>=cordx2+0.17)&&(Actualcordr3x-0.055>=ActualcordRx1)
		bbox=list(cordNx2-0.21:by1 (ActualcordRx0+0.04):by2))
		when((ActualcordRx1>cordNx2-0.17)&&(ActualcordRx0>=cordx2+0.17)&&(Actualcordr3x-0.055<ActualcordRx1)
		bbox=list(Actualcordr3x-0.095:by1 (ActualcordRx0+0.04):by2))
		when((ActualcordRx1>cordNx2-0.17)&&(ActualcordRx0<cordx2+0.17)&&(Actualcordr3x-0.055>=ActualcordRx1)
		bbox=list(cordNx2-0.21:by1 (cordx2+0.21):by2))
		when((ActualcordRx1>cordNx2-0.17)&&(ActualcordRx0<cordx2+0.17)&&(Actualcordr3x-0.055<ActualcordRx1)
		bbox=list(Actualcordr3x-0.095:by1 (cordx2+0.21):by2)))
		when(ActualcordRx1<(cordNx2-0.03)
		Actualcordr3x=cordNx2-0.245
		when((ActualcordRx1<=cordNx2-0.17)&&(ActualcordRx0>=cordx2+0.17)&&(Actualcordr3x-0.055>=ActualcordRx1)
		bbox=list(ActualcordRx1-0.04:by1 (ActualcordRx0+0.04):by2))
		when((ActualcordRx1<=cordNx2-0.17)&&(ActualcordRx0>=cordx2+0.17)&&(Actualcordr3x-0.055<ActualcordRx1)
		bbox=list(Actualcordr3x-0.095:by1 (ActualcordRx0+0.04):by2))
		when((ActualcordRx1<=cordNx2-0.17)&&(ActualcordRx0<cordx2+0.17)&&(Actualcordr3x-0.055>=ActualcordRx1)
		bbox=list(ActualcordRx1-0.04:by1 (cordx2+0.21):by2))
		when((ActualcordRx1<=cordNx2-0.17)&&(ActualcordRx0<cordx2+0.17)&&(Actualcordr3x-0.055<ActualcordRx1)
		bbox=list(Actualcordr3x-0.095:by1 (cordx2+0.21):by2))
		when((ActualcordRx1>cordNx2-0.17)&&(ActualcordRx0>=cordx2+0.17)&&(Actualcordr3x-0.055>=ActualcordRx1)
		bbox=list(cordNx2-0.21:by1 (ActualcordRx0+0.04):by2))
		when((ActualcordRx1>cordNx2-0.17)&&(ActualcordRx0>=cordx2+0.17)&&(Actualcordr3x-0.055<ActualcordRx1)
		bbox=list(Actualcordr3x-0.095:by1 (ActualcordRx0+0.04):by2))
		when((ActualcordRx1>cordNx2-0.17)&&(ActualcordRx0<cordx2+0.17)&&(Actualcordr3x-0.055>=ActualcordRx1)
		bbox=list(cordNx2-0.21:by1 (cordx2+0.21):by2))
		when((ActualcordRx1>cordNx2-0.17)&&(ActualcordRx0<cordx2+0.17)&&(Actualcordr3x-0.055<ActualcordRx1)
		bbox=list(Actualcordr3x-0.095:by1 (cordx2+0.21):by2)))
		when(ActualrvLeft<(cordNx2-0.03)&&(ActualrvLeft<ActualcordRx1)
		when((ActualcordRx0>=cordx2+0.17)
		bbox=list(ActualrvLeft-0.04:by1 (ActualcordRx0+0.04):by2))
		when((ActualcordRx0<cordx2+0.17)
		bbox=list(ActualrvLeft-0.04:by1 (cordx2+0.21):by2))
		)
		LeftLeaf=caar(bbox)
		RightLeaf=caadr(bbox)-LeftLeaf
		dbSet(SHAPE bbox "bBox")) ; moves the M3 Power rails i.e the GND/Vdd
		when((SHAPE~>layerName=="PO")&&((bx1==0&&by1==0.05)||(bx1==0&&by1==0.18)||(bx1==0&&by1==0.31)||(bx1==0&&by1==0.44)||(bx1==0&&by1==0.57)||(bx1==0&&by1==0.7)||(bx1==0&&by1==0.83)||(bx1==0&&by1==0.96)||(bx1==0&&by1==1.09)||(bx1==0&&by1==1.35)||(bx1==0&&by1==1.48)||(bx1==0&&by1==1.61)||(bx1==0&&by1==1.74)||(bx1==0&&by1==1.87)||(bx1==0&&by1==2)||(bx1==0&&by1==2.13)||(bx1==0&&by1==2.26)||(bx1==0&&by1==2.39)||(bx1==0&&by1==2.52)||(bx1==0&&by1==2.65)||(bx1==0&&by1==2.78)||(bx1==0&&by1==2.91)||(bx1==0&&by1==3.04)||(bx1==0&&by1==3.17)||(bx1==0&&by1==3.3)||(bx1==0&&by1==3.43)||(bx1==0&&by1==3.56)||(bx1==0&&by1==3.69)||(bx1==0&&by1==3.82)||(bx1==0&&by1==3.95)||(bx1==0&&by1==4.08)||(bx1==0&&by1==4.21)||(bx1==0&&by1==4.34)||(bx1==0&&by1==4.47)||(bx1==0&&by1==4.6)||(bx1==0&&by1==4.99)||(bx1==0&&by1==5.12)||(bx1==0&&by1==5.51)||(bx1==0&&by1==5.64)||(bx1==0&&by1==5.77)||(bx1==0&&by1==5.9)||(bx1==0&&by1==6.03)||(bx1==0&&by1==6.16)||(bx1==0&&by1==6.29)||(bx1==0&&by1==6.42)||(bx1==0&&by1==6.55)||(bx1==0&&by1==6.68)||(bx1==0&&by1==6.81)||(bx1==0&&by1==6.94)||(bx1==0&&by1==7.07)||(bx1==0&&by1==7.2)||(bx1==0&&by1==7.33)||(bx1==0&&by1==7.46)||(bx1==0&&by1==7.59)||(bx1==0&&by1==7.72)||(bx1==0&&by1==7.85)||(bx1==0&&by1==7.98)||(bx1==0&&by1==8.11)||(bx1==0&&by1==8.24)||(bx1==0&&by1==8.37)||(bx1==0&&by1==8.5)||(bx1==0&&by1==8.63)||(bx1==0&&by1==8.76)||(bx1==0&&by1==8.89)||(bx1==0&&by1==9.02)||(bx1==0&&by1==9.15)||(bx1==0&&by1==9.28)||(bx1==0&&by1==9.41)||(bx1==0&&by1==9.54)||(bx1==0&&by1==9.67)||(bx1==0&&by1==9.8)||(bx1==0&&by1==9.93)||(bx1==0&&by1==10.06)||(bx1==0&&by1==10.19)||(bx1==0&&by1==10.32)||(bx1==0&&by1==10.45)||(bx1==0&&by1==10.58)||(bx1==0&&by1==10.71)||(bx1==0&&by1==10.84)||(bx1==0&&by1==10.97)||(bx1==0&&by1==11.1)||(bx1==0&&by1==11.23)||(bx1==0&&by1==11.36)||(bx1==0&&by1==11.49)||(bx1==0&&by1==11.62)||(bx1==0&&by1==11.75)||(bx1==0&&by1==11.88)||(bx1==0&&by1==12.01)||(bx1==0&&by1==12.14)||(bx1==0&&by1==12.27)||(bx1==0&&by1==12.4))
		when(ActualcordRx1>=(cordNx2-0.03)
		Actualcordr3x=cordNx2+0.015
		when((ActualcordRx1<=cordNx2-0.17)&&(ActualcordRx0>=cordx2+0.17)&&(Actualcordr3x-0.055>=ActualcordRx1)
		bbox=list(ActualcordRx1-0.04:by1 (ActualcordRx0+0.04):by2))
		when((ActualcordRx1<=cordNx2-0.17)&&(ActualcordRx0>=cordx2+0.17)&&(Actualcordr3x-0.055<ActualcordRx1)
		bbox=list(Actualcordr3x-0.095:by1 (ActualcordRx0+0.04):by2))
		when((ActualcordRx1<=cordNx2-0.17)&&(ActualcordRx0<cordx2+0.17)&&(Actualcordr3x-0.055>=ActualcordRx1)
		bbox=list(ActualcordRx1-0.04:by1 (cordx2+0.21):by2))
		when((ActualcordRx1<=cordNx2-0.17)&&(ActualcordRx0<cordx2+0.17)&&(Actualcordr3x-0.055<ActualcordRx1)
		bbox=list(Actualcordr3x-0.095:by1 (cordx2+0.21):by2))
		when((ActualcordRx1>cordNx2-0.17)&&(ActualcordRx0>=cordx2+0.17)&&(Actualcordr3x-0.055>=ActualcordRx1)
		bbox=list(cordNx2-0.21:by1 (ActualcordRx0+0.04):by2))
		when((ActualcordRx1>cordNx2-0.17)&&(ActualcordRx0>=cordx2+0.17)&&(Actualcordr3x-0.055<ActualcordRx1)
		bbox=list(Actualcordr3x-0.095:by1 (ActualcordRx0+0.04):by2))
		when((ActualcordRx1>cordNx2-0.17)&&(ActualcordRx0<cordx2+0.17)&&(Actualcordr3x-0.055>=ActualcordRx1)
		bbox=list(cordNx2-0.21:by1 (cordx2+0.21):by2))
		when((ActualcordRx1>cordNx2-0.17)&&(ActualcordRx0<cordx2+0.17)&&(Actualcordr3x-0.055<ActualcordRx1)
		bbox=list(Actualcordr3x-0.095:by1 (cordx2+0.21):by2)))
		when(ActualcordRx1<(cordNx2-0.03)
		Actualcordr3x=cordNx2-0.245
		when((ActualcordRx1<=cordNx2-0.17)&&(ActualcordRx0>=cordx2+0.17)&&(Actualcordr3x-0.055>=ActualcordRx1)
		bbox=list(ActualcordRx1-0.04:by1 (ActualcordRx0+0.04):by2))
		when((ActualcordRx1<=cordNx2-0.17)&&(ActualcordRx0>=cordx2+0.17)&&(Actualcordr3x-0.055<ActualcordRx1)
		bbox=list(Actualcordr3x-0.095:by1 (ActualcordRx0+0.04):by2))
		when((ActualcordRx1<=cordNx2-0.17)&&(ActualcordRx0<cordx2+0.17)&&(Actualcordr3x-0.055>=ActualcordRx1)
		bbox=list(ActualcordRx1-0.04:by1 (cordx2+0.21):by2))
		when((ActualcordRx1<=cordNx2-0.17)&&(ActualcordRx0<cordx2+0.17)&&(Actualcordr3x-0.055<ActualcordRx1)
		bbox=list(Actualcordr3x-0.095:by1 (cordx2+0.21):by2))
		when((ActualcordRx1>cordNx2-0.17)&&(ActualcordRx0>=cordx2+0.17)&&(Actualcordr3x-0.055>=ActualcordRx1)
		bbox=list(cordNx2-0.21:by1 (ActualcordRx0+0.04):by2))
		when((ActualcordRx1>cordNx2-0.17)&&(ActualcordRx0>=cordx2+0.17)&&(Actualcordr3x-0.055<ActualcordRx1)
		bbox=list(Actualcordr3x-0.095:by1 (ActualcordRx0+0.04):by2))
		when((ActualcordRx1>cordNx2-0.17)&&(ActualcordRx0<cordx2+0.17)&&(Actualcordr3x-0.055>=ActualcordRx1)
		bbox=list(cordNx2-0.21:by1 (cordx2+0.21):by2))
		when((ActualcordRx1>cordNx2-0.17)&&(ActualcordRx0<cordx2+0.17)&&(Actualcordr3x-0.055<ActualcordRx1)
		bbox=list(Actualcordr3x-0.095:by1 (cordx2+0.21):by2)))
		dbSet(SHAPE bbox "bBox")) ; moves the dummy poly grid layers
		when((SHAPE~>layerName=="PO")&&bx1==0&&by2==12.48
		when(ActualcordRx1>=(cordNx2-0.03)
		Actualcordr3x=cordNx2+0.015
		when((ActualcordRx1<=cordNx2-0.17)&&(Actualcordr3x-0.055>=ActualcordRx1)
		bbox=list(ActualcordRx1-0.04:by1 ActualcordRx1:by2))
		when((ActualcordRx1<=cordNx2-0.17)&&(Actualcordr3x-0.055<ActualcordRx1)
		bbox=list(Actualcordr3x-0.095:by1 Actualcordr3x-0.055:by2))
		when((ActualcordRx1>cordNx2-0.17)&&(Actualcordr3x-0.055>=ActualcordRx1)
		bbox=list(cordNx2-0.21:by1 (cordNx2-0.17):by2))
		when((ActualcordRx1>cordNx2-0.17)&&(Actualcordr3x-0.055<ActualcordRx1)
		bbox=list(Actualcordr3x-0.095:by1 (Actualcordr3x-0.055):by2)))
		when(ActualcordRx1<(cordNx2-0.03)
		Actualcordr3x=cordNx2-0.245
		when((ActualcordRx1<=cordNx2-0.17)&&(Actualcordr3x-0.055>=ActualcordRx1)
		bbox=list(ActualcordRx1-0.04:by1 ActualcordRx1:by2))
		when((ActualcordRx1<=cordNx2-0.17)&&(Actualcordr3x-0.055<ActualcordRx1)
		bbox=list(Actualcordr3x-0.095:by1 Actualcordr3x-0.055:by2))
		when((ActualcordRx1>cordNx2-0.17)&&(Actualcordr3x-0.055>=ActualcordRx1)
		bbox=list(cordNx2-0.21:by1 (cordNx2-0.17):by2))
		when((ActualcordRx1>cordNx2-0.17)&&(Actualcordr3x-0.055<ActualcordRx1)
		bbox=list(Actualcordr3x-0.095:by1 (Actualcordr3x-0.055):by2)))
		dbSet(SHAPE bbox "bBox")) ; moves the cut poly layers on the left side of the leaf cell
		when((SHAPE~>layerName=="PO")&&((bx1==0.485&&by1==4.86)||(bx1==0.485&&by1==4.73))
		bbox=list(bx1:by1 (ActualcordRx0+0.04):by2)
		dbSet(SHAPE bbox "bBox"))
		when((SHAPE~>layerName=="PO")&&((bx1==0&&by1==5.38)||(bx1==0&&by1==5.25))
		bbox=list(ActualcordRx1-0.04:by1 bx2:by2)
		dbSet(SHAPE bbox "bBox"))
		when((SHAPE~>layerName=="PO")&&bx1==1.52&&by2==12.48
		when((ActualcordRx0>=cordx2+0.17)
		bbox=list(ActualcordRx0:by1 (ActualcordRx0+0.04):by2))
		when((ActualcordRx0<cordx2+0.17)
		bbox=list(cordx2+0.17:by1 (cordx2+0.21):by2))
		dbSet(SHAPE bbox "bBox")) ; moves the cut poly layers on the right side of the leaf cell
		when((SHAPE~>layerName=="NP")&&((bx1==0&&by2==0.17)||(bx1==0&&by2==12.48))
		when(ActualcordRx1>=(cordNx2-0.03)
		Actualcordr3x=cordNx2+0.015
		when((ActualcordRx1<=cordNx2-0.17)&&(ActualcordRx0>=cordx2+0.17)&&(Actualcordr3x-0.055>=ActualcordRx1)
		bbox=list(ActualcordRx1-0.04:by1 (ActualcordRx0+0.04):by2))
		when((ActualcordRx1<=cordNx2-0.17)&&(ActualcordRx0>=cordx2+0.17)&&(Actualcordr3x-0.055<ActualcordRx1)
		bbox=list(Actualcordr3x-0.095:by1 (ActualcordRx0+0.04):by2))
		when((ActualcordRx1<=cordNx2-0.17)&&(ActualcordRx0<cordx2+0.17)&&(Actualcordr3x-0.055>=ActualcordRx1)
		bbox=list(ActualcordRx1-0.04:by1 (cordx2+0.21):by2))
		when((ActualcordRx1<=cordNx2-0.17)&&(ActualcordRx0<cordx2+0.17)&&(Actualcordr3x-0.055<ActualcordRx1)
		bbox=list(Actualcordr3x-0.095:by1 (cordx2+0.21):by2))
		when((ActualcordRx1>cordNx2-0.17)&&(ActualcordRx0>=cordx2+0.17)&&(Actualcordr3x-0.055>=ActualcordRx1)
		bbox=list(cordNx2-0.21:by1 (ActualcordRx0+0.04):by2))
		when((ActualcordRx1>cordNx2-0.17)&&(ActualcordRx0>=cordx2+0.17)&&(Actualcordr3x-0.055<ActualcordRx1)
		bbox=list(Actualcordr3x-0.095:by1 (ActualcordRx0+0.04):by2))
		when((ActualcordRx1>cordNx2-0.17)&&(ActualcordRx0<cordx2+0.17)&&(Actualcordr3x-0.055>=ActualcordRx1)
		bbox=list(cordNx2-0.21:by1 (cordx2+0.21):by2))
		when((ActualcordRx1>cordNx2-0.17)&&(ActualcordRx0<cordx2+0.17)&&(Actualcordr3x-0.055<ActualcordRx1)
		bbox=list(Actualcordr3x-0.095:by1 (cordx2+0.21):by2)))
		when(ActualcordRx1<(cordNx2-0.03)
		Actualcordr3x=cordNx2-0.245
		when((ActualcordRx1<=cordNx2-0.17)&&(ActualcordRx0>=cordx2+0.17)&&(Actualcordr3x-0.055>=ActualcordRx1)
		bbox=list(ActualcordRx1-0.04:by1 (ActualcordRx0+0.04):by2))
		when((ActualcordRx1<=cordNx2-0.17)&&(ActualcordRx0>=cordx2+0.17)&&(Actualcordr3x-0.055<ActualcordRx1)
		bbox=list(Actualcordr3x-0.095:by1 (ActualcordRx0+0.04):by2))
		when((ActualcordRx1<=cordNx2-0.17)&&(ActualcordRx0<cordx2+0.17)&&(Actualcordr3x-0.055>=ActualcordRx1)
		bbox=list(ActualcordRx1-0.04:by1 (cordx2+0.21):by2))
		when((ActualcordRx1<=cordNx2-0.17)&&(ActualcordRx0<cordx2+0.17)&&(Actualcordr3x-0.055<ActualcordRx1)
		bbox=list(Actualcordr3x-0.095:by1 (cordx2+0.21):by2))
		when((ActualcordRx1>cordNx2-0.17)&&(ActualcordRx0>=cordx2+0.17)&&(Actualcordr3x-0.055>=ActualcordRx1)
		bbox=list(cordNx2-0.21:by1 (ActualcordRx0+0.04):by2))
		when((ActualcordRx1>cordNx2-0.17)&&(ActualcordRx0>=cordx2+0.17)&&(Actualcordr3x-0.055<ActualcordRx1)
		bbox=list(Actualcordr3x-0.095:by1 (ActualcordRx0+0.04):by2))
		when((ActualcordRx1>cordNx2-0.17)&&(ActualcordRx0<cordx2+0.17)&&(Actualcordr3x-0.055>=ActualcordRx1)
		bbox=list(cordNx2-0.21:by1 (cordx2+0.21):by2))
		when((ActualcordRx1>cordNx2-0.17)&&(ActualcordRx0<cordx2+0.17)&&(Actualcordr3x-0.055<ActualcordRx1)
		bbox=list(Actualcordr3x-0.095:by1 (cordx2+0.21):by2)))
		dbCreateRect(CellView NWellLPP bbox)
		dbSet(SHAPE bbox "bBox"))
		when((SHAPE~>layerName=="NP")&&(by1==8.71&&by2==12.31)
		when(ActualcordRx1>=(cordNx2-0.03)
		Actualcordr3x=cordNx2+0.015
		when((ActualcordRx1<=cordNx2-0.17)&&(Actualcordr3x-0.055>=ActualcordRx1)
		bbox=list(ActualcordRx1-0.04:by1 bx2:by2))
		when((ActualcordRx1<=cordNx2-0.17)&&(Actualcordr3x-0.055<ActualcordRx1)
		bbox=list(Actualcordr3x-0.095:by1 bx2:by2))
		when((ActualcordRx1>cordNx2-0.17)&&(Actualcordr3x-0.055>=ActualcordRx1)
		bbox=list(cordNx2-0.21:by1 bx2:by2))
		when((ActualcordRx1>cordNx2-0.17)&&(Actualcordr3x-0.055<ActualcordRx1)
		bbox=list(Actualcordr3x-0.095:by1 bx2:by2)))
		when(ActualcordRx1<(cordNx2-0.03)
		Actualcordr3x=cordNx2-0.245
		when((ActualcordRx1<=cordNx2-0.17)&&(Actualcordr3x-0.055>=ActualcordRx1)
		bbox=list(ActualcordRx1-0.04:by1 bx2:by2))
		when((ActualcordRx1<=cordNx2-0.17)&&(Actualcordr3x-0.055<ActualcordRx1)
		bbox=list(Actualcordr3x-0.095:by1 bx2:by2))
		when((ActualcordRx1>cordNx2-0.17)&&(Actualcordr3x-0.055>=ActualcordRx1)
		bbox=list(cordNx2-0.21:by1 bx2:by2))
		when((ActualcordRx1>cordNx2-0.17)&&(Actualcordr3x-0.055<ActualcordRx1)
		bbox=list(Actualcordr3x-0.095:by1 bx2:by2)))
		dbSet(SHAPE bbox "bBox"))
		when((SHAPE~>layerName=="NP")&&(by1==7.15&&by2==8.71)
		when(ActualcordRx1>=(cordNx2-0.03)
		Actualcordr3x=cordNx2+0.015
		when((ActualcordRx1<=cordNx2-0.17)&&(Actualcordr3x-0.055>=ActualcordRx1)
		bbox=list(ActualcordRx1-0.04:by1 cordrvx2:by2))
		when((ActualcordRx1<=cordNx2-0.17)&&(Actualcordr3x-0.055<ActualcordRx1)
		bbox=list(Actualcordr3x-0.095:by1 cordrvx2:by2))
		when((ActualcordRx1>cordNx2-0.17)&&(Actualcordr3x-0.055>=ActualcordRx1)
		bbox=list(cordNx2-0.21:by1 cordrvx2:by2))
		when((ActualcordRx1>cordNx2-0.17)&&(Actualcordr3x-0.055<ActualcordRx1)
		bbox=list(Actualcordr3x-0.095:by1 cordrvx2:by2)))
		when(ActualcordRx1<(cordNx2-0.03)
		Actualcordr3x=cordNx2-0.245
		when((ActualcordRx1<=cordNx2-0.17)&&(Actualcordr3x-0.055>=ActualcordRx1)
		bbox=list(ActualcordRx1-0.04:by1 cordrvx2:by2))
		when((ActualcordRx1<=cordNx2-0.17)&&(Actualcordr3x-0.055<ActualcordRx1)
		bbox=list(Actualcordr3x-0.095:by1 cordrvx2:by2))
		when((ActualcordRx1>cordNx2-0.17)&&(Actualcordr3x-0.055>=ActualcordRx1)
		bbox=list(cordNx2-0.21:by1 cordrvx2:by2))
		when((ActualcordRx1>cordNx2-0.17)&&(Actualcordr3x-0.055<ActualcordRx1)
		bbox=list(Actualcordr3x-0.095:by1 cordrvx2:by2)))
		dbSet(SHAPE bbox "bBox"))
		when((SHAPE~>layerName=="NP")&&(by1==0.17&&by2==4.615)
		when(ActualcordRx1>=(cordNx2-0.03)
		Actualcordr3x=cordNx2+0.015
		when((ActualcordRx1<=cordNx2-0.17)&&(Actualcordr3x-0.055>=ActualcordRx1)
		bbox=list(ActualcordRx1-0.04:by1 bx2:by2))
		when((ActualcordRx1<=cordNx2-0.17)&&(Actualcordr3x-0.055<ActualcordRx1)
		bbox=list(Actualcordr3x-0.095:by1 bx2:by2))
		when((ActualcordRx1>cordNx2-0.17)&&(Actualcordr3x-0.055>=ActualcordRx1)
		bbox=list(cordNx2-0.21:by1 bx2:by2))
		when((ActualcordRx1>cordNx2-0.17)&&(Actualcordr3x-0.055<ActualcordRx1)
		bbox=list(Actualcordr3x-0.095:by1 bx2:by2)))
		when(ActualcordRx1<(cordNx2-0.03)
		Actualcordr3x=cordNx2-0.245
		when((ActualcordRx1<=cordNx2-0.17)&&(Actualcordr3x-0.055>=ActualcordRx1)
		bbox=list(ActualcordRx1-0.04:by1 bx2:by2))
		when((ActualcordRx1<=cordNx2-0.17)&&(Actualcordr3x-0.055<ActualcordRx1)
		bbox=list(Actualcordr3x-0.095:by1 bx2:by2))
		when((ActualcordRx1>cordNx2-0.17)&&(Actualcordr3x-0.055>=ActualcordRx1)
		bbox=list(cordNx2-0.21:by1 bx2:by2))
		when((ActualcordRx1>cordNx2-0.17)&&(Actualcordr3x-0.055<ActualcordRx1)
		bbox=list(Actualcordr3x-0.095:by1 bx2:by2)))
		dbSet(SHAPE bbox "bBox"))
		when(((SHAPE~>layerName=="NW")||(SHAPE~>layerName=="PM"))&&(by1==8.71&&by2==12.35)
		when((ActualcordRx0>=cordx2+0.17)
		bbox=list(bx1:by1 (ActualcordRx0+0.04):by2))
		when((ActualcordRx0<cordx2+0.17)
		bbox=list(bx1:by1 (cordx2+0.21):by2))
		dbSet(SHAPE bbox "bBox"))
		when(((SHAPE~>layerName=="NW")||(SHAPE~>layerName=="PM"))&&(by1==7.15&&by2==8.71)
		when((ActualcordRx0>=cordx2+0.17)
		bbox=list(cordrvx2:by1 (ActualcordRx0+0.04):by2))
		when((ActualcordRx0<cordx2+0.17)
		bbox=list(cordrvx2:by1 (cordx2+0.21):by2))
		dbSet(SHAPE bbox "bBox"))
		when(((SHAPE~>layerName=="NW")||(SHAPE~>layerName=="PM"))&&(by1==5.33&&by2==7.15)
		when((ActualcordRx0>=cordx2+0.17)
		bbox=list(cordrvPx:by1 (ActualcordRx0+0.04):by2))
		when((ActualcordRx0<cordx2+0.17)
		bbox=list(cordrvPx:by1 (cordx2+0.21):by2))
		dbSet(SHAPE bbox "bBox"))
		when(((SHAPE~>layerName=="NW")||(SHAPE~>layerName=="PM"))&&(by1==0.13&&by2==5.33)
		when((ActualcordRx0>=cordx2+0.17)
		bbox=list(bx1:by1 (ActualcordRx0+0.04):by2))
		when((ActualcordRx0<cordx2+0.17)
		bbox=list(bx1:by1 (cordx2+0.21):by2))
		dbSet(SHAPE bbox "bBox"))
		when(SHAPE~>layerName=="PP"&&by1==8.71&&by2==12.31
		when((ActualcordRx0>=cordx2+0.17)
		bbox=list(bx1:by1 (ActualcordRx0+0.04):by2))
		when((ActualcordRx0<cordx2+0.17)
		bbox=list(bx1:by1 (cordx2+0.21):by2))
		dbSet(SHAPE bbox "bBox"))
		when(SHAPE~>layerName=="PP"&&by1==7.15&&by2==8.71
		when((ActualcordRx0>=cordx2+0.17)
		bbox=list(cordrvx2:by1 (ActualcordRx0+0.04):by2))
		when((ActualcordRx0<cordx2+0.17)
		bbox=list(cordrvx2:by1 (cordx2+0.21):by2))
		dbSet(SHAPE bbox "bBox"))
		when(SHAPE~>layerName=="PP"&&by1==0.17&&by2==4.93
		when((ActualcordRx0>=cordx2+0.17)
		bbox=list(bx1:by1 (ActualcordRx0+0.04):by2))
		when((ActualcordRx0<cordx2+0.17)
		bbox=list(bx1:by1 (cordx2+0.21):by2))
		dbSet(SHAPE bbox "bBox"))
		when(SHAPE~>layerName=="PP"&&by1==5.455&&by2==7.15
		when((ActualcordRx0>=cordx2+0.17)
		bbox=list(cordrvPx:by1 (ActualcordRx0+0.04):by2))
		when((ActualcordRx0<cordx2+0.17)
		bbox=list(cordrvPx:by1 (cordx2+0.21):by2))
		dbSet(SHAPE bbox "bBox"))
		when(SHAPE~>layerName=="PP"&&bx1==1.25&&by1==4.93
		when((ActualcordRx0>=cordx2+0.17)
		bbox=list(bx1:by1 (ActualcordRx0+0.04):by2))
		when((ActualcordRx0<cordx2+0.17)
		bbox=list(bx1:by1 (cordx2+0.21):by2))
		dbSet(SHAPE bbox "bBox"))
		when(SHAPE~>layerName=="PP"&&bx1==0.51&&by1==4.93
		pnts=list(x1:y1 cordrvPx:y2 cordrvPx:y3 x4:y4 x5:y5 x6:y6)
		dbSet(SHAPE pnts "points"))
		when(SHAPE~>layerName=="NP"&&by1==5.33&&by2==7.15
		when(ActualcordRx1>=(cordNx2-0.03)
		Actualcordr3x=cordNx2+0.015
		when((ActualcordRx1<=cordNx2-0.17)&&(Actualcordr3x-0.055>=ActualcordRx1)
		bbox=list(ActualcordRx1-0.04:by1 cordrvPx:by2))
		when((ActualcordRx1<=cordNx2-0.17)&&(Actualcordr3x-0.055<ActualcordRx1)
		bbox=list(Actualcordr3x-0.095:by1 cordrvPx:by2))
		when((ActualcordRx1>cordNx2-0.17)&&(Actualcordr3x-0.055>=ActualcordRx1)
		bbox=list(cordNx2-0.21:by1 cordrvPx:by2))
		when((ActualcordRx1>cordNx2-0.17)&&(Actualcordr3x-0.055<ActualcordRx1)
		bbox=list(Actualcordr3x-0.095:by1 cordrvPx:by2)))
		when(ActualcordRx1<(cordNx2-0.03)
		Actualcordr3x=cordNx2-0.245
		when((ActualcordRx1<=cordNx2-0.17)&&(Actualcordr3x-0.055>=ActualcordRx1)
		bbox=list(ActualcordRx1-0.04:by1 cordrvPx:by2))
		when((ActualcordRx1<=cordNx2-0.17)&&(Actualcordr3x-0.055<ActualcordRx1)
		bbox=list(Actualcordr3x-0.095:by1 cordrvPx:by2))
		when((ActualcordRx1>cordNx2-0.17)&&(Actualcordr3x-0.055>=ActualcordRx1)
		bbox=list(cordNx2-0.21:by1 cordrvPx:by2))
		when((ActualcordRx1>cordNx2-0.17)&&(Actualcordr3x-0.055<ActualcordRx1)
		bbox=list(Actualcordr3x-0.095:by1 cordrvPx:by2)))
		dbSet(SHAPE bbox "bBox"))
		when(SHAPE~>layerName=="NP"&&bx1==0&&by1==4.615
		when(ActualcordRx1>=(cordNx2-0.03)
		Actualcordr3x=cordNx2+0.015
		when((ActualcordRx1<=cordNx2-0.17)&&(Actualcordr3x-0.055>=ActualcordRx1)
		bbox=list(ActualcordRx1-0.04:by1 bx2:by2))
		when((ActualcordRx1<=cordNx2-0.17)&&(Actualcordr3x-0.055<ActualcordRx1)
		bbox=list(Actualcordr3x-0.095:by1 bx2:by2))
		when((ActualcordRx1>cordNx2-0.17)&&(Actualcordr3x-0.055>=ActualcordRx1)
		bbox=list(cordNx2-0.21:by1 bx2:by2))
		when((ActualcordRx1>cordNx2-0.17)&&(Actualcordr3x-0.055<ActualcordRx1)
		bbox=list(Actualcordr3x-0.095:by1 bx2:by2)))
		when(ActualcordRx1<(cordNx2-0.03)
		Actualcordr3x=cordNx2-0.245
		when((ActualcordRx1<=cordNx2-0.17)&&(Actualcordr3x-0.055>=ActualcordRx1)
		bbox=list(ActualcordRx1-0.04:by1 bx2:by2))
		when((ActualcordRx1<=cordNx2-0.17)&&(Actualcordr3x-0.055<ActualcordRx1)
		bbox=list(Actualcordr3x-0.095:by1 bx2:by2))
		when((ActualcordRx1>cordNx2-0.17)&&(Actualcordr3x-0.055>=ActualcordRx1)
		bbox=list(cordNx2-0.21:by1 bx2:by2))
		when((ActualcordRx1>cordNx2-0.17)&&(Actualcordr3x-0.055<ActualcordRx1)
		bbox=list(Actualcordr3x-0.095:by1 bx2:by2)))
		dbSet(SHAPE bbox "bBox"))
		))

	foreach(VIA CellView->vias
		(let (vx1 vy1 bx1 by1 bx2 by2 vx1 vy1 orgn)
		bx1=caar(VIA~>bBox)
		by1=cadar(VIA~>bBox)
		bx2=caadr(VIA~>bBox)
		by2=cadadr(VIA~>bBox)
		vx1=car(VIA~>origin)
		vy1=cadr(VIA~>origin)
		when((VIA~>viaHeader~>viaDefName=="M2_M1") && (VIA~>net~>name=="_r.3")
		when(ActualcordRx1>=(cordNx2-0.03)
		orgn=((cordNx2+0.015):vy1))
		when(ActualcordRx1<(cordNx2-0.03)
		orgn=((cordNx2-0.245):vy1))
		dbSet(VIA orgn "origin")) ; moves M2_M1 vias as per new spec
		when(((VIA~>viaHeader~>viaDefName=="M2_M1") || (VIA~>viaHeader~>viaDefName=="M3_M2")) && ((VIA~>net~>name=="L.3") || (VIA~>net~>name=="L.2") || (VIA~>net~>name=="L.1") || (VIA~>net~>name=="L.0"))
		orgn=(cordNx2-0.115:vy1)
		dbSet(VIA orgn "origin")) ; moves M2_M1 vias as per new spec
		when((VIA~>viaHeader~>viaDefName=="M2_M1") && (VIA~>net~>name=="_r.2")
		orgn=((cordx2-0.145):vy1)
		dbSet(VIA orgn "origin")) ; moves M2_M1 vias as per new spec
		when((VIA~>viaHeader~>viaDefName=="M2_M1") && (VIA~>net~>name=="_Reset")
		orgn=((cordx2-0.015):vy1)
		dbSet(VIA orgn "origin")) ; moves M2_M1 vias as per new spec
		when((VIA~>viaHeader~>viaDefName=="M2_M1") && (VIA~>net~>name=="_r.0")
		orgn=((cordx2-0.145):vy1)
		dbSet(VIA orgn "origin")) ; moves M2_M1 vias as per new spec
		when(((VIA~>viaHeader~>viaDefName=="M2_M1") || (VIA~>viaHeader~>viaDefName=="M3_M2")) && (VIA~>net~>name=="R.e")
		orgn=(cordx2+0.115:vy1)
		dbSet(VIA orgn "origin")) ; moves M2_M1 vias as per new spec
		when((VIA~>viaHeader~>viaDefName=="M2_M1") && (VIA~>net~>name=="L.e")&&vx1==0.825&&vy1==4.29
		when((cordLey2==4.25)||(cordLey2==4.12)||(cordLey2==3.99)||(cordLey2==3.86)
		dbDeleteObject(VIA)))
		when((VIA~>viaHeader~>viaDefName=="M2_M1") && (VIA~>net~>name=="L.e")&&vx1==0.825&&vy1==4.03
		when((cordLey2==3.99)||(cordLey2==3.86)
		dbDeleteObject(VIA)))
		when((VIA~>viaHeader~>viaDefName=="M2_M1")&&(vx1==0.825)&&(vy1==1.17)
		when(cordR0y1==1.34
		dbDeleteObject(VIA)))
		when((VIA~>viaHeader~>viaDefName=="M2_M1")&&(vx1==0.825)&&(vy1==9.75)
		when(cordR2y2==9.58
		dbDeleteObject(VIA)))
			))
			BufCreatePrBound(CellView)
))

(defun CopyBuffer_fullheight ( CellView ViewName LibName CellName )
		(let (xy1 xy2 XY bx1 bx2 by1 by2 buf rightcord RightCord pnts SHAPE)

 		when(minusp(LeftLeaf)
		buf = dbCreateInstByMasterName(CellView LibName CellName "scratch" "buf" 0.0:0 "R0"))
		when(plusp(LeftLeaf)
		buf = dbCreateInstByMasterName(CellView LibName CellName "scratch" "buf" LeftLeaf:0 "R0"))
		when(LeftLeaf==0
		buf = dbCreateInstByMasterName(CellView LibName CellName "scratch" "buf" 0:0 "R0"))
		foreach(INST CellView~>instances
		xy1=car(INST~>xy)
		xy2=cadr(INST~>xy)
		bx1=caar(INST~>bBox)
		by1=cadar(INST~>bBox)
		bx2=caadr(INST~>bBox)
		by2=cadadr(INST~>bBox)
		XY=(-bx1:xy2)
		dbSet(INST XY "xy"))
		dbFlattenInst(buf 1)
		rightcord=round(((RightLeaf/0.26)/0.5)*0.5+0.5)
		RightCord=0.26*rightcord
		pnts=list(0:by1 0:by2 RightCord:by2 RightCord:by1)
		dbCreatePRBoundary(CellView pnts)
	foreach(SHAPE CellView->shapes
		(let (bx1 bx2 by1 by2 x1 x2 x3 x4 x5 x6 x7 x8 y1 y2 y3 y4 y5 y6 y7 y8 xy1 xy2 pnts bbox orgn)
		bx1=caar(SHAPE~>bBox)
		by1=cadar(SHAPE~>bBox)
		bx2=caadr(SHAPE~>bBox)
		by2=cadadr(SHAPE~>bBox)
		xy1=car(SHAPE~>xy)
		xy2=cadr(SHAPE~>xy)
		x1=caar(SHAPE~>points)
		y1=cadar(SHAPE~>points)
		x2=caadr(SHAPE~>points)
		y2=cadadr(SHAPE~>points)
		x3=caaddr(SHAPE~>points)
		y3=car(cdaddr(SHAPE~>points))
		x4=car(cadddr(SHAPE~>points))
		y4=cadr(cadddr(SHAPE~>points))
		x5=caar(cddddr(SHAPE~>points))
		y5=cadar(cddddr(SHAPE~>points))
		x6=caadr(cddddr(SHAPE~>points))
		y6=cadadr(cddddr(SHAPE~>points))
		x7=caaddr(cddddr(SHAPE~>points))
		y7=car(cdaddr(cddddr(SHAPE~>points)))
		x8=car(cadddr(cddddr(SHAPE~>points)))
		y8=cadr(cadddr(cddddr(SHAPE~>points)))
 		when((SHAPE~>layerName=="NP")&&((by2==4.615&&by1==0.17)||(by2==5.33&&by1==4.615)||(by2==7.15&&by1==5.33)||(by2==8.71&&by1==7.15)||(by2==12.31&&by1==8.71))
		bbox=list(0:by1 bx2:by2)
		dbSet(SHAPE bbox "bBox"));moves the NP layer on the left side of the gate
		when(((SHAPE~>layerName=="NW")||(SHAPE~>layerName=="NP"))&&by2==12.48&&by1==12.31
		bbox=list(0:by1 RightCord:by2+0.13)
		dbSet(SHAPE bbox "bBox")) ; moves the NW/NP layers on top
		when(((SHAPE~>layerName=="NW")||(SHAPE~>layerName=="NP"))&&(by2==0.17&&by1==0)
		bbox=list(0:by1-0.13 RightCord:by2)
		dbSet(SHAPE bbox "bBox")) ; moves the NW/NP layers on bottom
		when(((SHAPE~>layerName=="NW")||(SHAPE~>layerName=="PM"))&&((by2==12.35&&by1==8.71)||(by2==8.71&&by1==7.15)||(by2==7.15&&by1==5.33)||(by2==5.33&&by1==0.13))
		bbox=list(bx1:by1 RightCord:by2)
		dbSet(SHAPE bbox "bBox")) ; moves the NW/PM layer on the right side of the leaf cell
		when((SHAPE~>layerName=="PP")&&((by2==4.93&&by1==0.17)||(by2==5.455&&by1==4.93)||(by2==7.15&&by1==5.455)||(by2==8.71&&by1==7.15)||(by2==12.31&&by1==8.71))
		bbox=list(bx1:by1 RightCord:by2)
		dbSet(SHAPE bbox "bBox")) ; moves the PP layer on the right side of the leaf cell
		when((SHAPE~>layerName=="M3")&&((by2==0.095&&by1==0.025)||(by2==1.535&&by1==1.465)||(by2==1.655&&by1==1.585)||(by2==3.095&&by1==3.025)||(by2==3.215&&by1==3.145)||(by2==4.655&&by1==4.585)||(by2==4.775&&by1==4.705)||(by2==6.215&&by1==6.145)||(by2==6.335&&by1==6.265)||(by2==7.775&&by1==7.705)||(by2==7.895&&by1==7.825)||(by2==9.335&&by1==9.265)||(by2==9.455&&by1==9.385)||(by2==10.895&&by1==10.825)||(by2==11.015&&by1==10.945)||(by2==12.455&&by1==12.385))
		bbox=list(bx1:by1 RightCord:by2)
		dbSet(SHAPE bbox "bBox")) ;moves the M3 power grid(GND/Vdd) wires
		when((SHAPE~>layerName=="M3")&&((bx1!=0.04&&by1==1.335&&by2==1.395)||(bx1!=0.04&&by1==2.895&&by2==2.955)||(bx1!=0.04&&by1==3.285&&by2==3.345)||(bx1!=0.04&&by1==9.135&&by2==9.195)||(bx1!=0.04&&by1==10.695&&by2==10.755))
		bbox=list(bx1:by1 RightCord-0.04:by2)
		dbSet(SHAPE bbox "bBox")) ;moves the M3 R.o/R.1/R.e pins on the left side of the leaf cell
		when((SHAPE~>layerName=="M3")&&by2==6.465&&by1==6.405
		bbox=list(bx1:by1 RightCord-0.04:by2)
		dbSet(SHAPE bbox "bBox")) ;moves the M3 _RESET pin
		))
		DeleteGridPoly(?CellView CellView)
		DrawGridPoly(?CellView CellView)
		ddDeleteObj(ddGetObj(LibName CellName "scratch"))
		dbSave(CellView)
		dbPurge(CellView)
 )
)

(defun CopyBuffer_template ( CellView ViewName LibName CellName )
		(let (xy1 xy2 XY bx1 bx2 by1 by2 buf rightcord RightCord pnts SHAPE)
 		when(minusp(LeftLeaf)
		buf = dbCreateInstByMasterName(CellView LibName CellName "scratch" "buf" 0.0:0 "R0"))
		when(plusp(LeftLeaf)
		buf = dbCreateInstByMasterName(CellView LibName CellName "scratch" "buf" 0:0 "R0"))
		when(LeftLeaf==0
		buf = dbCreateInstByMasterName(CellView LibName CellName "scratch" "buf" 0:0 "R0"))
		foreach(INST CellView~>instances
		xy1=car(INST~>xy)
		xy2=cadr(INST~>xy)
		bx1=caar(INST~>bBox)
		by1=cadar(INST~>bBox)
		bx2=caadr(INST~>bBox)
		by2=cadadr(INST~>bBox)
		XY=(-bx1:xy2)
		dbSet(INST XY "xy"))
		dbFlattenInst(buf 1)
		rightcord=round(((RightLeaf/0.26)/0.5)*0.5+0.5)
		RightCord=0.26*rightcord
		pnts=list(0:by1 0:by2 RightCord:by2 RightCord:by1)
		dbCreatePRBoundary(CellView pnts)
	foreach(INST CellView->instances
		(let (xy1 xy2 XY bx1 bx2 by1 by2)
		xy1=car(INST~>xy)
		xy2=cadr(INST~>xy)
		bx1=caar(INST~>bBox)
		by1=cadar(INST~>bBox)
		bx2=caadr(INST~>bBox)
		by2=cadadr(INST~>bBox)
		when((INST->cellName=="stack.NPLUG.0")
		XY=(0.155:xy2)
		dbSet(INST XY "xy"))
		when((INST->cellName=="stack.PPLUG.0")
		XY=(RightCord-0.155:xy2)
		dbSet(INST XY "xy"))
		))
	foreach(SHAPE CellView->shapes
		(let (bx1 bx2 by1 by2 x1 x2 x3 x4 x5 x6 x7 x8 y1 y2 y3 y4 y5 y6 y7 y8 xy1 xy2 pnts bbox orgn)
		bx1=caar(SHAPE~>bBox)
		by1=cadar(SHAPE~>bBox)
		bx2=caadr(SHAPE~>bBox)
		by2=cadadr(SHAPE~>bBox)
		xy1=car(SHAPE~>xy)
		xy2=cadr(SHAPE~>xy)
		x1=caar(SHAPE~>points)
		y1=cadar(SHAPE~>points)
		x2=caadr(SHAPE~>points)
		y2=cadadr(SHAPE~>points)
		x3=caaddr(SHAPE~>points)
		y3=car(cdaddr(SHAPE~>points))
		x4=car(cadddr(SHAPE~>points))
		y4=cadr(cadddr(SHAPE~>points))
		x5=caar(cddddr(SHAPE~>points))
		y5=cadar(cddddr(SHAPE~>points))
		x6=caadr(cddddr(SHAPE~>points))
		y6=cadadr(cddddr(SHAPE~>points))
		x7=caaddr(cddddr(SHAPE~>points))
		y7=car(cdaddr(cddddr(SHAPE~>points)))
		x8=car(cadddr(cddddr(SHAPE~>points)))
		y8=cadr(cadddr(cddddr(SHAPE~>points)))
 		when((SHAPE~>layerName=="NP")&&by2==6.07&&by1==0.17
		pnts=list(x1:y1 0:y2 0:y3 0.26:y4 0.26:y5 0:y6 0:y7 x8:y8)
		dbSet(SHAPE pnts "points"));moves the NP layer on the left side of the gate
		when((SHAPE~>layerName=="NP")&&by2==6.24&&by1==6.07
		bbox=list(0:by1 RightCord:by2+0.13)
		dbCreateRect(CellView "NW" bbox)
		dbSet(SHAPE bbox "bBox")) ; moves the NW/NP layers on top
		when((SHAPE~>layerName=="NP")&&(by2==0.17&&by1==0)
		bbox=list(0:by1-0.13 RightCord:by2)
		dbCreateRect(CellView "NW" bbox)
		dbSet(SHAPE bbox "bBox")) ; moves the NW/NP layers on bottom
		when(((SHAPE~>layerName=="NW")||(SHAPE~>layerName=="PM"))&&by2==6.11&&by1==0.13
		bbox=list(bx1:by1 RightCord:by2)
		dbSet(SHAPE bbox "bBox")) ; moves the NW/PM layer on the right side of the leaf cell
		when((SHAPE~>layerName=="PP")&&by2==6.07&&by1==0.17
		pnts=list(RightCord:y1 RightCord-0.26:y2 RightCord-0.26:y3 RightCord:y4 RightCord:y5 x6:y6 x7:y7 RightCord:y8)
		dbSet(SHAPE pnts "points")) ; moves the PP layer on the right side of the leaf cell
		when((SHAPE~>layerName=="M3")&&((by2==0.095&&by1==0.025)||(by2==1.535&&by1==1.465)||(by2==1.655&&by1==1.585)||(by2==3.095&&by1==3.025)||(by2==3.215&&by1==3.145)||(by2==4.655&&by1==4.585)||(by2==4.775&&by1==4.705)||(by2==6.215&&by1==6.145))
		bbox=list(0:by1 RightCord:by2)
		dbSet(SHAPE bbox "bBox")) ;moves the M3 power grid(GND/Vdd) wires
		when((SHAPE~>layerName=="M3")&&((bx1!=0.04&&by1==0.295&&by2==0.355)||(bx1!=0.04&&by1==1.855&&by2==1.915)||(bx1!=0.04&&by1==2.895&&by2==2.955)||(bx1!=0.04&&by1==4.455&&by2==4.515)||(bx1!=0.04&&by1==5.035&&by2==4.975))
		bbox=list(bx1:by1 RightCord-0.04:by2)
		dbSet(SHAPE bbox "bBox")) ;moves the M3 R.o/R.1/R.e pins on the left side of the leaf cell
		when((SHAPE~>layerName=="M3")&&by2==3.475&&by1==3.415
		bbox=list(0.04:by1 RightCord-0.04:by2)
		dbSet(SHAPE bbox "bBox")) ;moves the M3 _RESET pin
		when((SHAPE~>layerName=="M1")&&by1==1.995&&by2==2.25
		pnts=list(x1:y1 RightCord-0.155:y2 RightCord-0.155:y3)
		dbSet(SHAPE pnts "points"))
		when((SHAPE~>layerName=="M1")&&by2==2.5&&by1==2.185
		pnts=list(x1:y1 0.155:y2 0.155:y3)
		dbSet(SHAPE pnts "points"))
		when((SHAPE~>layerName=="PP")&&by2==2.38&&by1==1.855
		bbox=list(0:by1 0.05:by2)
		dbSet(SHAPE bbox "bBox"))
		when((SHAPE~>layerName=="NP")&&by2==2.355&&by1==1.83
		bbox=list(RightCord-0.09:by1 RightCord:by2)
		dbSet(SHAPE bbox "bBox"))
		))
		DeleteGridPoly(?CellView CellView)
		DrawGridPoly(?CellView CellView)
		ddDeleteObj(ddGetObj(LibName CellName "scratch"))
		dbSave(CellView)
		dbPurge(CellView)
 )
)

(defun CopyBuffer_template1 ( CellView ViewName LibName CellName )
		(let (xy1 xy2 XY bx1 bx2 by1 by2 buf rightcord RightCord pnts SHAPE)
		buf = dbCreateInstByMasterName(CellView LibName CellName "scratch" "buf" 0:0 "R0")
		foreach(INST CellView~>instances
		xy1=car(INST~>xy)
		xy2=cadr(INST~>xy)
		bx1=caar(INST~>bBox)
		by1=cadar(INST~>bBox)
		bx2=caadr(INST~>bBox)
		by2=cadadr(INST~>bBox)
		XY=(-bx1:xy2)
		dbSet(INST XY "xy"))
		dbFlattenInst(buf 1)
		rightcord=round(((RightLeaf/0.26)/0.5)*0.5+0.5)
		RightCord=0.26*rightcord
		pnts=list(0:by1 0:by2 RightCord:by2 RightCord:by1)
		dbCreatePRBoundary(CellView pnts)
	foreach(INST CellView->instances
		(let (xy1 xy2 XY bx1 bx2 by1 by2)
		xy1=car(INST~>xy)
		xy2=cadr(INST~>xy)
		bx1=caar(INST~>bBox)
		by1=cadar(INST~>bBox)
		bx2=caadr(INST~>bBox)
		by2=cadadr(INST~>bBox)
		when((INST->cellName=="stack.NPLUG.0")&&(xy2==3.38)
		XY=(0.13:xy2)
		dbSet(INST XY "xy"))
		when((INST->cellName=="stack.NPLUG.0")&&(xy2==2.335)
		XY=(RightCord-0.16:xy2)
		dbSet(INST XY "xy"))
		))
	foreach(SHAPE CellView->shapes
		(let (bx1 bx2 by1 by2 x1 x2 x3 x4 x5 x6 x7 x8 y1 y2 y3 y4 y5 y6 y7 y8 xy1 xy2 pnts bbox orgn)
		bx1=caar(SHAPE~>bBox)
		by1=cadar(SHAPE~>bBox)
		bx2=caadr(SHAPE~>bBox)
		by2=cadadr(SHAPE~>bBox)
		xy1=car(SHAPE~>xy)
		xy2=cadr(SHAPE~>xy)
		x1=caar(SHAPE~>points)
		y1=cadar(SHAPE~>points)
		x2=caadr(SHAPE~>points)
		y2=cadadr(SHAPE~>points)
		x3=caaddr(SHAPE~>points)
		y3=car(cdaddr(SHAPE~>points))
		x4=car(cadddr(SHAPE~>points))
		y4=cadr(cadddr(SHAPE~>points))
		x5=caar(cddddr(SHAPE~>points))
		y5=cadar(cddddr(SHAPE~>points))
		x6=caadr(cddddr(SHAPE~>points))
		y6=cadadr(cddddr(SHAPE~>points))
		x7=caaddr(cddddr(SHAPE~>points))
		y7=car(cdaddr(cddddr(SHAPE~>points)))
		x8=car(cadddr(cddddr(SHAPE~>points)))
		y8=cadr(cadddr(cddddr(SHAPE~>points)))
 		when((SHAPE~>layerName=="NP")&&by2==6.24&&by1==0
		pnts=list(x1:y1 0:y2 0:y3 0.235:y4 0.235:y5 0:y6 0:y7 x8:y8)
		dbSet(SHAPE pnts "points"));moves the NP layer on the left side of the gate
		when((SHAPE~>layerName=="NP")&&by2==6.24&&by1==6.07
		bbox=list(0:by1 RightCord:by2+0.13)
		dbCreateRect(CellView "NW" bbox)
		dbSet(SHAPE bbox "bBox")) ; moves the NW/NP layers on top
		when((SHAPE~>layerName=="NP")&&(by2==0.17&&by1==0)
		bbox=list(0:by1-0.13 RightCord:by2)
		dbCreateRect(CellView "NW" bbox)
		dbSet(SHAPE bbox "bBox")) ; moves the NW/NP layers on bottom
		when((SHAPE~>layerName=="NP")&&by2==6.24&&by1==2.99
		pnts=list(RightCord:y1 x2:y2 x3:y3 x4:y4 x5:y5 RightCord:y6)
		dbSet(SHAPE pnts "points")) ; moves the NP layer on the right side of the leaf cell
		when((SHAPE~>layerName=="NP")&&by2==2.99&&by1==0
		pnts=list(RightCord:y1 RightCord-0.265:y2 RightCord-0.265:y3 RightCord:y4 RightCord:y5 x6:y6 x7:y7 RightCord:y8)
		dbSet(SHAPE pnts "points")) ; moves the NP layer on the right side of the leaf cell
		when((SHAPE~>layerName=="M3")&&((by2==0.095&&by1==0.025)||(by2==1.535&&by1==1.465)||(by2==1.655&&by1==1.585)||(by2==3.095&&by1==3.025)||(by2==3.215&&by1==3.145)||(by2==4.655&&by1==4.585)||(by2==4.775&&by1==4.705)||(by2==6.215&&by1==6.145))
		bbox=list(0:by1 RightCord:by2)
		dbSet(SHAPE bbox "bBox")) ;moves the M3 power grid(GND/Vdd) wires
		when((SHAPE~>layerName=="M3")&&((bx1!=0.04&&by1==0.295&&by2==0.355)||(bx1!=0.04&&by1==1.855&&by2==1.915)||(bx1!=0.04&&by1==2.895&&by2==2.955)||(bx1!=0.04&&by1==4.455&&by2==4.515)||(bx1!=0.04&&by1==5.035&&by2==4.975))
		bbox=list(bx1:by1 RightCord-0.04:by2)
		dbSet(SHAPE bbox "bBox")) ;moves the M3 R.o/R.1/R.e pins on the left side of the leaf cell
		when((SHAPE~>layerName=="M3")&&by2==3.475&&by1==3.415
		bbox=list(0.04:by1 RightCord-0.04:by2)
		dbSet(SHAPE bbox "bBox")) ;moves the M3 _RESET pin
		when((SHAPE~>layerName=="M1")&&by2==2.5&&by1==2.305
		pnts=list(x1:y1 RightCord-0.16:y2 RightCord-0.16:y3)
		dbSet(SHAPE pnts "points"))
		when((SHAPE~>layerName=="PP")&&by2==3.905&&by1==3.38
		bbox=list(0:by1 0.08:by2)
		dbSet(SHAPE bbox "bBox"))
		when((SHAPE~>layerName=="PP")&&by1==2.335&&by2==2.86
		bbox=list(RightCord-0.055:by1 RightCord:by2)
		dbSet(SHAPE bbox "bBox"))
		))
		DeleteGridPoly(?CellView CellView)
		DrawGridPoly(?CellView CellView)
		ddDeleteObj(ddGetObj(LibName CellName "scratch"))
		dbSave(CellView)
		dbPurge(CellView)
 )
)

(defun CopyBuffer_template2 ( CellView ViewName LibName CellName )
		(let (xy1 xy2 XY bx1 bx2 by1 by2 buf rightcord RightCord pnts SHAPE)
		buf = dbCreateInstByMasterName(CellView LibName CellName "scratch" "buf" 0:0 "R0")
		foreach(INST CellView~>instances
		xy1=car(INST~>xy)
		xy2=cadr(INST~>xy)
		bx1=caar(INST~>bBox)
		by1=cadar(INST~>bBox)
		bx2=caadr(INST~>bBox)
		by2=cadadr(INST~>bBox)
		XY=(-bx1:xy2)
		dbSet(INST XY "xy"))
		dbFlattenInst(buf 1)
		rightcord=round(((RightLeaf/0.26)/0.5)*0.5+0.5)
		RightCord=0.26*rightcord
		pnts=list(0:by1 0:by2 RightCord:by2 RightCord:by1)
		dbCreatePRBoundary(CellView pnts)
	foreach(INST CellView->instances
		(let (xy1 xy2 XY bx1 bx2 by1 by2)
		xy1=car(INST~>xy)
		xy2=cadr(INST~>xy)
		bx1=caar(INST~>bBox)
		by1=cadar(INST~>bBox)
		bx2=caadr(INST~>bBox)
		by2=cadadr(INST~>bBox)
		when((INST->cellName=="stack.NPLUG.0")&&(xy2==3.12)
		XY=(0.13:xy2)
		dbSet(INST XY "xy"))
		when((INST->cellName=="stack.NPLUG.0")&&(xy2==2.865)
		XY=(RightCord-0.13:xy2)
		dbSet(INST XY "xy"))
		))
	foreach(SHAPE CellView->shapes
		(let (bx1 bx2 by1 by2 x1 x2 x3 x4 x5 x6 x7 x8 y1 y2 y3 y4 y5 y6 y7 y8 xy1 xy2 pnts bbox orgn)
		bx1=caar(SHAPE~>bBox)
		by1=cadar(SHAPE~>bBox)
		bx2=caadr(SHAPE~>bBox)
		by2=cadadr(SHAPE~>bBox)
		xy1=car(SHAPE~>xy)
		xy2=cadr(SHAPE~>xy)
		x1=caar(SHAPE~>points)
		y1=cadar(SHAPE~>points)
		x2=caadr(SHAPE~>points)
		y2=cadadr(SHAPE~>points)
		x3=caaddr(SHAPE~>points)
		y3=car(cdaddr(SHAPE~>points))
		x4=car(cadddr(SHAPE~>points))
		y4=cadr(cadddr(SHAPE~>points))
		x5=caar(cddddr(SHAPE~>points))
		y5=cadar(cddddr(SHAPE~>points))
		x6=caadr(cddddr(SHAPE~>points))
		y6=cadadr(cddddr(SHAPE~>points))
		x7=caaddr(cddddr(SHAPE~>points))
		y7=car(cdaddr(cddddr(SHAPE~>points)))
		x8=car(cadddr(cddddr(SHAPE~>points)))
		y8=cadr(cadddr(cddddr(SHAPE~>points)))
 		when((SHAPE~>layerName=="NP")&&by2==6.24&&by1==0
		pnts=list(x1:y1 0:y2 0:y3 0.235:y4 0.235:y5 0:y6 0:y7 x8:y8)
		dbSet(SHAPE pnts "points"));moves the NP layer on the left side of the gate
		when((SHAPE~>layerName=="NP")&&by2==6.24&&by1==6.07
		bbox=list(0:by1 RightCord:by2+0.13)
		dbCreateRect(CellView "NW" bbox)
		dbSet(SHAPE bbox "bBox")) ; moves the NW/NP layers on top
		when((SHAPE~>layerName=="NP")&&(by2==0.17&&by1==0)
		bbox=list(0:by1-0.13 RightCord:by2)
		dbCreateRect(CellView "NW" bbox)
		dbSet(SHAPE bbox "bBox")) ; moves the NW/NP layers on bottom
		when((SHAPE~>layerName=="NP")&&by2==6.24&&by1==2.34
		pnts=list(RightCord-0.235:y1 RightCord-0.235:y2 RightCord:y3 RightCord:y4 x5:y5 x6:y6)
		dbSet(SHAPE pnts "points")) ; moves the NP layer on the right side of the leaf cell
		when((SHAPE~>layerName=="NP")&&by2==2.34&&by1==0
		bbox=list(bx1:by1 RightCord:by2)
		dbSet(SHAPE bbox "bBox")) ; moves the NP layer on the right side of the leaf cell
		when((SHAPE~>layerName=="M3")&&((by2==0.095&&by1==0.025)||(by2==1.535&&by1==1.465)||(by2==1.655&&by1==1.585)||(by2==3.095&&by1==3.025)||(by2==3.215&&by1==3.145)||(by2==4.655&&by1==4.585)||(by2==4.775&&by1==4.705)||(by2==6.215&&by1==6.145))
		bbox=list(0:by1 RightCord:by2)
		dbSet(SHAPE bbox "bBox")) ;moves the M3 power grid(GND/Vdd) wires
		when((SHAPE~>layerName=="M3")&&((bx1!=0.04&&by1==0.295&&by2==0.355)||(bx1!=0.04&&by1==1.855&&by2==1.915)||(bx1!=0.04&&by1==2.895&&by2==2.955)||(bx1!=0.04&&by1==4.455&&by2==4.515)||(bx1!=0.04&&by1==5.035&&by2==4.975))
		bbox=list(bx1:by1 RightCord-0.04:by2)
		dbSet(SHAPE bbox "bBox")) ;moves the M3 R.o/R.1/R.e pins on the left side of the leaf cell
		when((SHAPE~>layerName=="M3")&&by2==3.475&&by1==3.415
		bbox=list(0.04:by1 RightCord-0.04:by2)
		dbSet(SHAPE bbox "bBox")) ;moves the M3 _RESET pin
		when((SHAPE~>layerName=="M1")&&by2==2.76&&by1==2.44
		pnts=list(x1:y1 RightCord-0.13:y2 RightCord-0.13:y3)
		dbSet(SHAPE pnts "points"))
		when((SHAPE~>layerName=="PP")&&by2==3.645&&by1==3.12
		bbox=list(0:by1 0.08:by2)
		dbSet(SHAPE bbox "bBox"))
		when((SHAPE~>layerName=="PP")&&by1==2.34&&by2==2.865
		bbox=list(RightCord-0.08:by1 RightCord:by2)
		dbSet(SHAPE bbox "bBox"))
		))
		DeleteGridPoly(?CellView CellView)
		DrawGridPoly(?CellView CellView)
		ddDeleteObj(ddGetObj(LibName CellName "scratch"))
		dbSave(CellView)
		dbPurge(CellView)
 )
)

(defun BufferCreator ( CellName ViewName )
    let( ( k l m n y s z ce  cel piecess piecesss cv ncv mcv lcv vcv TemplateCellName pieces LibName Temp LeftLeaf RightLeaf chk)
        pieces=parseString( CellName "." )
        LibName=nth( 0 pieces )
        chk=nth( 3 pieces )
	k="0"
	l="0"
	m="0"
	n="0"
        for( n 1 length(pieces)-3
            LibName = strcat( LibName "." nth( n pieces )))
        cv=nrOpenCellViewReadable( LibName CellName ViewName )
	when(chk=="BUF_1of4"
        TemplateCellName = "lib.buffer.half.Template_BUF_1of4.buftemplate"
	Temp = "Template3")
	when(chk=="BUF_H_1of4"
        TemplateCellName = "lib.buffer.half.Template_BUF_1of4.buftemplate"
	Temp = Template())
;	Temp = "Template2"

	when(Temp=="Template"
	mcv=nrOpenCellViewReadable( LibName TemplateCellName "template")

        when( cv != nil
            printf( "Buffer type already exists %s\n" CellName)
            )
	when( mcv == nil
	    printf("Template Cell doesnot exists %s\n" TemplateCellName))
         when( ((cv == nil)&&(mcv != nil))
            printf("yes\n")
            betterCopyCellView(mcv LibName CellName "scratch" nil nil t)
            ncv = nrOpenCellViewWritable( LibName CellName "scratch" )
	    MakeBuffer1( ncv ViewName)
		dbSave(ncv)
		dbPurge(ncv)
            lcv = nrOpenCellViewWritable( LibName CellName ViewName )
		CopyBuffer_template( lcv ViewName LibName CellName ))
		)

	when(Temp=="Template1"
	printf("Template1\n")
	mcv=nrOpenCellViewReadable( LibName TemplateCellName "template1")

        when( cv != nil
            printf( "Buffer type already exists %s\n" CellName)
            )
	when( mcv == nil
	    printf("Template Cell doesnot exists %s\n" TemplateCellName))
         when( ((cv == nil)&&(mcv != nil))
            printf("yes\n")
            betterCopyCellView(mcv LibName CellName "scratch" nil nil t)
            ncv = nrOpenCellViewWritable( LibName CellName "scratch" )
	    MakeBuffer( ncv ViewName)
		dbSave(ncv)
		dbPurge(ncv)
            lcv = nrOpenCellViewWritable( LibName CellName ViewName )
		CopyBuffer_template1( lcv ViewName LibName CellName ))
	)

	when(Temp=="Template2"
	printf("Template2\n")
	mcv=nrOpenCellViewReadable( LibName TemplateCellName "template2")

        when( cv != nil
            printf( "Buffer type already exists %s\n" CellName)
            )
	when( mcv == nil
	    printf("Template Cell doesnot exists %s\n" TemplateCellName))
         when( ((cv == nil)&&(mcv != nil))
            printf("Yes\n")
            betterCopyCellView(mcv LibName CellName "scratch" nil nil t)
            ncv = nrOpenCellViewWritable( LibName CellName "scratch" )
	    MakeBuffer2( ncv ViewName)
		dbSave(ncv)
		dbPurge(ncv)
            lcv = nrOpenCellViewWritable( LibName CellName ViewName )
		CopyBuffer_template2( lcv ViewName LibName CellName ))
            )
	when(Temp=="Template3"
	printf("Template3\n")
	mcv=nrOpenCellViewReadable( LibName TemplateCellName "template_fullheight")

        when( cv != nil
            printf( "Buffer type already exists %s\n" CellName)
            )
	when( mcv == nil
	    printf("Template Cell doesnot exists %s\n" TemplateCellName))
         when( ((cv == nil)&&(mcv != nil))
            printf("Yes\n")
            betterCopyCellView(mcv LibName CellName "scratch" nil nil t)
            ncv = nrOpenCellViewWritable( LibName CellName "scratch" )
	    MakeBuffer_FullHeight( ncv ViewName)
		dbSave(ncv)
		dbPurge(ncv)
            lcv = nrOpenCellViewWritable( LibName CellName ViewName )
		CopyBuffer_fullheight( lcv ViewName LibName CellName ))
            )

    )
 )

(defun Parameter ( CellName)
	(let (fl pieces piece specname initialpath InitialPath IntermediatePath finalpath k text Variable1 cst FinalPath variable1 variable2 variable3 variable4 Variable3 Variable4 var3 var4 Var3 varb4 Varb3 Var4 Outfl chk)
	pieces=parseString( CellName "." )
	specname=nth( 4 pieces )
	chk=nth( 3 pieces)
	cst=".cast"
	when(chk=="BUF_1of4"
	IntermediatePath="/lib/buffer/half/BUF_1of4/")
	when(chk=="BUF_H_1of4"
	IntermediatePath="/lib/buffer/half/BUF_H_1of4/")
	initialpath=ConfigFileGetValue(TheCDSConfigTable "CAST_PATH")
	piece=parseString( initialpath ":" )
	InitialPath=nth( 1 piece )
	finalpath=strcat(InitialPath IntermediatePath specname cst)
	fl = infile(finalpath)
	Outfl = outfile("Parameter.txt" "w")
	while( gets(k fl) != nil
  	text = parseString( k " \n")
	Variable1 = nth(0 text)
	when((Variable1=="XReset")||(Variable1=="X_Reset")||(Variable1=="XL.e")||(Variable1=="XR.0")||(Variable1=="XR.1")||(Variable1=="XR.2")||(Variable1=="XR.3")
	variable1=car(parseString( Variable1 "X" ))
	variable2=nth(6 text)
	Variable3=nth(7 text)
	Var3=parseString( Variable3 "=" )
	Varb3=nth( 1 Var3)
	var3=parseString( Varb3 "u" )
	variable3=nth( 0 var3)
	Variable4=nth(8 text)
	Var4=parseString( Variable4 "=" )
	Varb4=nth( 1 Var4)
	var4=parseString( Varb4 "u" )
	variable4=nth( 0 var4)
	fprintf(Outfl "%s" variable1 )
	fprintf(Outfl " %s" variable2 )
	fprintf(Outfl " %s" variable3 )
	fprintf(Outfl " %s\n" variable4 )
	)
	when((Variable1=="X_r.0")||(Variable1=="X_r.1")||(Variable1=="X_r.2")||(Variable1=="X_r.3")
	variable1=car(parseString( Variable1 "X" ))
	variable2=nth(8 text)
	Variable3=nth(9 text)
	Var3=parseString( Variable3 "=" )
	Varb3=nth( 1 Var3)
	var3=parseString( Varb3 "u" )
	variable3=nth( 0 var3)
	Variable4=nth(10 text)
	Var4=parseString( Variable4 "=" )
	Varb4=nth( 1 Var4)
	var4=parseString( Varb4 "u" )
	variable4=nth( 0 var4)
	fprintf(Outfl "%s" variable1 )
	fprintf(Outfl " %s" variable2 )
	fprintf(Outfl " %s" variable3 )
	fprintf(Outfl " %s\n" variable4 )
	)
	when((Variable1=="Xrv")
	variable1=car(parseString( Variable1 "X" ))
	variable2=nth(10 text)
	Variable3=nth(11 text)
	Var3=parseString( Variable3 "=" )
	Varb3=nth( 1 Var3)
	var3=parseString( Varb3 "u" )
	variable3=nth( 0 var3)
	Variable4=nth(12 text)
	Var4=parseString( Variable4 "=" )
	Varb4=nth( 1 Var4)
	var4=parseString( Varb4 "u" )
	variable4=nth( 0 var4)
	fprintf(Outfl "%s" variable1 )
	fprintf(Outfl " %s" variable2 )
	fprintf(Outfl " %s" variable3 )
	fprintf(Outfl " %s\n" variable4 )
	)

)
	close(Outfl)
	close(fl)
	))

(defun BC ( CellName)

;	fl = infile("buf.txt")
;	while( gets(k fl) != nil
;  	text = parseString( k " \n")
;  	CellName = nth(0 text)
	printf("Cell is %s\n" CellName)
	Parameter(CellName)
  	BufferCreator(CellName "layout")
)

defun( BufCreatePrBound (CellView)
    (let (
          lpps
          bBox
          x1 x2 y1 y2
          Grid
         )
      Grid=ManufacturingGrid*MicronsPerMeter
      bBox=CellView~>bBox
      x1=min(caar(bBox) caadr(bBox))
      x2=max(caar(bBox) caadr(bBox))
      y1=min(cadar(bBox) cadadr(bBox))
      y2=max(cadar(bBox) cadadr(bBox))
      x1=floor(x1/Grid)*Grid
      y1=floor(y1/Grid)*Grid
      x2=ceiling(x2/Grid)*Grid
      y2=ceiling(y2/Grid)*Grid
      bBox=list( x1:y1 x2:y2 )
      lpps=setof( lpp CellView~>lpps lpp~>layerName==car(BoundaryLPP) )
      foreach( shape CellView->shapes
        when( shape->lpp==BoundaryLPP
          dbDeleteObject( shape )
        )
      )
      llcorner=car(CellView->bBox)
      urcorner=cadr(CellView->bBox)
      ulcorner=(list car(llcorner) cadr(urcorner)  )
      lrcorner=(list car(urcorner) cadr(llcorner)  )
      dbCreatePRBoundary( CellView list(llcorner lrcorner urcorner ulcorner) )

      dbSave( CellView )
    )
)

//SOCFuseGen
//SOCFuseGen Automatically generated by AcesXLSX2SystemRDL.pl
//SOCFuseGen Version: 2.26
//SOCFuseGen User: kmoses1
//SOCFuseGen Timestamp: Wed Jan 15 09:54:10 2014
//SOCFuseGen

`include "fuse_udp.rdl"

  addrmap tlm_fuse {
    field default_field {
      //**** DO NOT MODIFY CODE BELOW ****
      <% foreach $prop (keys %FieldProps) { %>
        <%=$prop%> = <%=$FieldProps{$prop}%>;
      <% } %>
      //**** DO NOT MODIFY CODE ABOVE ****
  
      // Description of this register field.
      desc = "This is the default field any register that instantiates this field will inherit all of the properties that are assigned in this field.";
    };

    TableType = "Fuse IP Template 2.5";
    PrivatePort = false;
    CmplFmt = 1;
    LegacyConverted = false;
    FuseMemLimit = "";
    StrapMemLimit = "";

    reg tlm_fuse {
      regwidth = 32;  // make blueprint happy 

      default_field fuse_1 = 1'h0;
      fuse_1->name = "fuse_1";
      fuse_1->FUSE_WIDTH = 8;
      fuse_1->RcvrAddr = 0;
      fuse_1->StartBit = 0;
      fuse_1->FuseDefaultValue = 8'hCA;
      fuse_1->Group = "DF";
      fuse_1->Category = "IntelHVM";
      fuse_1->ArrayType = "HS";
      fuse_1->LLDD = false;
      fuse_1->RequestType = "Group0";
      fuse_1->Shared = false;
      fuse_1->SharedTag = "";
      fuse_1->PullOnce = false;
      fuse_1->BlkOnDbg = false;
      fuse_1->VFOvrdDisable = false;
      fuse_1->JTagRD = false;
      fuse_1->JTagWR = false;
      fuse_1->CSRRD = false;
      fuse_1->CSRWR = false;
      fuse_1->RD4Err = false;
      fuse_1->LockoutValidIDTag = "1";
      fuse_1->Owner = "km";
      fuse_1->ValDestRTLSignal = "";
      fuse_1->PerformanceFuse = false;
      fuse_1->PowerFuse = true;
      fuse_1->EncodingLabels = "Enable, 0x0";
      fuse_1->desc = "fuse 1";
      fuse_1->misc = "";

      default_field fuse_2 = 1'h0;
      fuse_2->name = "fuse_2";
      fuse_2->FUSE_WIDTH = 6;
      fuse_2->RcvrAddr = 1;
      fuse_2->StartBit = 0;
      fuse_2->FuseDefaultValue = 6'b100100;
      fuse_2->Group = "DF";
      fuse_2->Category = "IntelHVM";
      fuse_2->ArrayType = "HD";
      fuse_2->LLDD = false;
      fuse_2->RequestType = "Group0";
      fuse_2->Shared = false;
      fuse_2->SharedTag = "";
      fuse_2->PullOnce = false;
      fuse_2->BlkOnDbg = false;
      fuse_2->VFOvrdDisable = false;
      fuse_2->JTagRD = false;
      fuse_2->JTagWR = false;
      fuse_2->CSRRD = false;
      fuse_2->CSRWR = false;
      fuse_2->RD4Err = false;
      fuse_2->LockoutValidIDTag = "2";
      fuse_2->Owner = "km";
      fuse_2->ValDestRTLSignal = "";
      fuse_2->PerformanceFuse = true;
      fuse_2->PowerFuse = false;
      fuse_2->EncodingLabels = "Enable, 0x6";
      fuse_2->desc = "fuse 2";
      fuse_2->misc = "";

      default_field fuse_3 = 1'h0;
      fuse_3->name = "fuse_3";
      fuse_3->FUSE_WIDTH = 2;
      fuse_3->RcvrAddr = 1;
      fuse_3->StartBit = 6;
      fuse_3->FuseDefaultValue = 2'b11;
      fuse_3->Group = "DF";
      fuse_3->Category = "IntelHVM";
      fuse_3->ArrayType = "HD";
      fuse_3->LLDD = false;
      fuse_3->RequestType = "Group0";
      fuse_3->Shared = false;
      fuse_3->SharedTag = "";
      fuse_3->PullOnce = false;
      fuse_3->BlkOnDbg = false;
      fuse_3->VFOvrdDisable = false;
      fuse_3->JTagRD = false;
      fuse_3->JTagWR = false;
      fuse_3->CSRRD = false;
      fuse_3->CSRWR = false;
      fuse_3->RD4Err = false;
      fuse_3->LockoutValidIDTag = "2";
      fuse_3->Owner = "km";
      fuse_3->ValDestRTLSignal = "";
      fuse_3->PerformanceFuse = false;
      fuse_3->PowerFuse = false;
      fuse_3->EncodingLabels = "Enable, 0x0";
      fuse_3->desc = "fuse 3";
      fuse_3->misc = "";

      default_field fuse_4 = 1'h0;
      fuse_4->name = "fuse_4";
      fuse_4->FUSE_WIDTH = 8;
      fuse_4->RcvrAddr = 2;
      fuse_4->StartBit = 0;
      fuse_4->FuseDefaultValue = 8'hAD;
      fuse_4->Group = "DF";
      fuse_4->Category = "IntelHVM";
      fuse_4->ArrayType = "HD";
      fuse_4->LLDD = false;
      fuse_4->RequestType = "Group1";
      fuse_4->Shared = false;
      fuse_4->SharedTag = "";
      fuse_4->PullOnce = false;
      fuse_4->BlkOnDbg = false;
      fuse_4->VFOvrdDisable = false;
      fuse_4->JTagRD = false;
      fuse_4->JTagWR = false;
      fuse_4->CSRRD = false;
      fuse_4->CSRWR = false;
      fuse_4->RD4Err = false;
      fuse_4->LockoutValidIDTag = "3";
      fuse_4->Owner = "km";
      fuse_4->ValDestRTLSignal = "";
      fuse_4->PerformanceFuse = true;
      fuse_4->PowerFuse = false;
      fuse_4->EncodingLabels = "Enable, 0x6";
      fuse_4->desc = "fuse 4";
      fuse_4->misc = "";

    };
    tlm_fuse tlm_fuse;

  };


; Copyright (c) 2025 Intel Corporation.  All rights reserved.  See the file COPYRIGHT for more information.
; SPDX-License-Identifier: Apache-2.0

;;;;;;;;;;;;;;;;;;;;;;;;;;;;; Draw Grid Poly and CPO ;;;;;;;;;;;;;;;;;;;;;;;;;;;;;;;;;;

; identify tool version, set as a cell property
gridPolyVersion = 4

; find cells with old grid poly and edit them
oldGridPolyFilter = (lambda (CV)
                      (dbGetPropByName CV "LeafCell")->value=="TRUE" && (OldGridPoly CV))
(defun FindOldGridPolyLeaves (@key (CV (geGetEditCellView)))
  (FindSubcells ?filter oldGridPolyFilter ?action editCellAction)
  )

; Is CV gridPolyVersion < current gridPolyVersion?
(defun OldGridPoly (CV)
  !(dbGetPropByName CV "gridPolyVersion") ||
  (dbGetPropByName CV "gridPolyVersion")->value < gridPolyVersion
  )

; set the palette for manual CPO fixing
(defun CpoPalette ()
  (leSetEntryLayer (list "PO" "test1"))
  (leSetAllLayerVisible nil)
  (leSetAllLayerSelectable nil)
  (leSetLayerVisible (list "PO" "drawing") t)
  (leSetLayerVisible (list "PO" "grd") t)
  (leSetLayerVisible (list "PO" "test1") t)
  (leSetLayerVisible (list "PO" "block") t)
  (leSetLayerVisible (list "PO" "dummy1") t)
  (leSetLayerVisible (list "CO" "drawing") t)
  (leSetLayerVisible (list "OD" "drawing") t)
  (leSetLayerVisible (list "PM" "drawing1") t)
  (leSetLayerSelectable (list "PO" "grd") t)
  (leSetLayerSelectable (list "PO" "test1") t)
  (leSetLayerSelectable (list "PO" "block") t)
  (leSetLayerSelectable (list "PM" "drawing1") t)
  )

; set a property to indicate which tool version was used on a CV
(defun SetGridPolyVersion (CV)
  (dbReplaceProp CV "gridPolyVersion" "int" gridPolyVersion)
  )

; Set a property to identify auto-generated to grid poly and CPO
(defun SetGridPolyProp (obj)
  (dbReplaceProp obj "grd_poly" "boolean" t)
  )

; Delete auto-generated grid poly and CPO
(defun DeleteGridPoly (@key (CV (geGetEditCellView)))
  (foreach s (setof obj CV->shapes (dbGetPropByName obj "CPO")->value=="TRUE")
           (dbDeleteObject s)
  	   )
  (foreach s (setof obj CV->shapes (dbGetPropByName obj "grd_poly")->value=="TRUE")
           (dbDeleteObject s)
  	   )
  (dbSave CV)
  t
  )

; Count the overlaps on a given layer with bbox and bloat
(defun NumberOfOverlaps (CV lpp x0 y0 x1 y1 dx dy)
  (length (dbGetTrueOverlaps CV
                             (list x0-dx+MfgGrid:y0-dy+MfgGrid
                                   x1+dx-MfgGrid:y1+dy-MfgGrid)
                             lpp 32))
  )

; Return a list of the X coordinate of Scratch1LPP shapes that overlap bbox
(defun FindEdgesOfPM (CV x0 y0 x1 y1)
  (let (shapes result)
    shapes = (dbGetTrueOverlaps CV (list x0:y0 x1:y1) Scratch1LPP 32)
    (foreach shape shapes
             result = (cons (car (car  shape->bBox)) result)
             result = (cons (car (cadr shape->bBox)) result)
             )
    (sort result (lambda (a b) a<b))
    )
  )

; Find preferred locations to chop poly
(defun FindCPOLocationsFromPoly (CV x0 y0 x1 y1 dx)
  (let (shapes result)
    shapes = (dbGetTrueOverlaps CV (list x0:y0 x1:y1) Scratch2LPP 32)
    (foreach shape shapes
             result = (cons (car (car  shape->bBox))-dx result)
             result = (cons (car (cadr shape->bBox))+dx result)
             )
    (sort result (lambda (a b) a<b))
    )
  )

; Check if a CPO bbox would satisfy simple DRC rules.
; TODO: move technology dependent constants to PDK.
(defun IsLegalCPO (CV x0 y0 x1 y1 pm_edges)
  (and
   ; doesn't overlap with various layers
   (NumberOfOverlaps CV (list "PO" "drawing") x0 y0 x1 y1 -0.04  0.00 )==0
   (NumberOfOverlaps CV (list "PO" "test1")   x0 y0 x1 y1  0.30 -0.06 )==0
   (NumberOfOverlaps CV (list "PO" "test1")   x0 y0 x1 y1 CutPolySpacing CutPolySpacing)==0
   (NumberOfOverlaps CV (list "OD" "drawing") x0 y0 x1 y1  0.035 0.035)==0
   (NumberOfOverlaps CV (list "CO" "drawing") x0 y0 x1 y1  0.02  0.02 )==0
   (NumberOfOverlaps CV (list "PO" "block")   x0 y0 x1 y1  0.30 -0.06 )==0
   ; doesn't overlap badly with PM boundaries
   (or pm_edges==nil
       (setof x pm_edges (and x>x0-0.1 x<x1+0.1))==nil
       )
   )
  )

; draw a list of CPO rectangles
(defun DrawCPORects (CV todraw)
  (let (cpo cpos)
    (foreach bbox todraw
             cpo = (dbCreateRect CV (list "PO" "test1") bbox)
             cpos = (cons cpo cpos)
             (SetGridPolyProp cpo)
             )
    cpos
    )
  )

; Draw grid poly and CPO's automatically
(defun DrawGridPoly (@key (CV (geGetEditCellView)))
  (let (lpp poly_pitch poly_width min_poly_length cpo_width cpo_length overhang min_edge max_edge
            bbox cx0 cy0 cx1 cy1 rows
            ya y0 y1 xa y0 y1
            obj grid_poly block_shapes
            pm_edges poly_locs todraw cpos)

    ; delete old autogenerated grid poly and CPO
    (DeleteGridPoly ?CV CV)

    ; technology constants (TODO: move to PDK)
    lpp = (list "PO" "test1")
    poly_pitch = GridPolyPitch
    poly_width = 0.03
    min_poly_length = MinPolyArea/poly_width ; minimum distance between CPO
    min_po_length = 0.0115/poly_width ; minimum area of drawn PO
    poly_offset = 0.01 ; offset from edge of poly to center of CPO
    cpo_width  = CutPolyWidth
    cpo_length = CutPolyHeight
    overhang = 0.005 ; grid poly overhang PRBoundary
    max_edge = min_poly_length+cpo_width+poly_offset ; maximum distance to edge for poly block
    min_edge = 0.08 + overhang ; minimum distance to edge for poly block

    ; cell bounding box
    bbox = (GetPrbound CV)->bBox
    cx0 = (car (car bbox))
    cy0 = (cadr (car bbox))
    cx1 = (car (cadr bbox))
    cy1 = (cadr (cadr bbox))
    rows = (ceiling (cy1-cy0)/poly_pitch)

    ; draw boundary CPO
    x0 = cx0-cpo_width/2
    x1 = cx0+cpo_width/2
    (when (NumberOfOverlaps CV lpp x0 cy0 x1 cy1 0 0)==0
          (SetGridPolyProp (dbCreateRect CV lpp (list x0:cy0 x1:cy1))))
    x0 = cx1-cpo_width/2
    x1 = cx1+cpo_width/2
    (when (NumberOfOverlaps CV lpp x0 cy0 x1 cy1 0 0)==0
          (SetGridPolyProp (dbCreateRect CV lpp (list x0:cy0 x1:cy1))))

    ; draw uniform grid poly
    (for y 0 rows-1
         ya = cy0+(y+0.5)*poly_pitch
         y0 = ya-poly_width/2
         y1 = ya+poly_width/2
         obj = (dbCreateRect CV (list "PO" "grd") (list cx0-overhang:y0 cx1+overhang:y1))
         grid_poly = (cons obj grid_poly)
         )

    ; create scratch view with some flattened layer intersections
    obj = (ddGetObj CV->libName CV->cellName "cpo_scratch")
    (when obj (ddDeleteObj obj))
    CV2 = (betterCopyCellView CV CV->libName CV->cellName "cpo_scratch" nil nil t)
    (foreach inst CV2->instances (dbFlattenInst inst 32 t nil nil))
    (foreach via  CV2->vias      (dbFlattenInst via 32 t nil nil))
    (leMergeShapes (leLayerAnd CV2 (list "PM" "drawing1") (list "PO" "grd") Scratch1LPP))
    (leMergeShapes (leLayerAnd CV2 (list "PO" "drawing")  (list "PO" "grd") Scratch2LPP))
    (foreach shape (leMergeShapes (leLayerAnd CV2 (list "PO" "block")
                                              (list "PO" "block") (list "PO" "block")))
             block_shapes = (cons (dbCopyFig shape CV) block_shapes)
             )
    (dbSave CV2)

    ; add legal CPO sites aligned to left and right of poly ends
    (for y 0 rows-1
         ya = cy0+(y+0.5)*poly_pitch
         y0 = ya-cpo_length/2
         y1 = ya+cpo_length/2
         (when (NumberOfOverlaps CV (list "PO" "drawing") cx0 y0 cx1 y1 0 0)>0
               pm_edges = (FindEdgesOfPM CV2 cx0 ya cx1 ya)
               poly_locs = (FindCPOLocationsFromPoly CV2 cx0 ya cx1 ya poly_offset)
               (foreach xa poly_locs
                        x0 = xa-cpo_width/2
                        x1 = xa+cpo_width/2
                        (when (IsLegalCPO CV x0 y0 x1 y1 pm_edges)
                          todraw = (cons (list x0:y0 x1:y1) todraw)
                          )
                        )
               )
         )

    ; add legal CPO sites aligned to PM edges
    (for y 0 rows-1
         ya = cy0+(y+0.5)*poly_pitch
         y0 = ya-cpo_length/2
         y1 = ya+cpo_length/2
         (when (NumberOfOverlaps CV (list "PO" "drawing") cx0 y0 cx1 y1 0 0)>0
               pm_edges = (FindEdgesOfPM CV2 cx0 ya cx1 ya)
               (foreach xa pm_edges
                        x0 = xa-cpo_width/2
                        x1 = xa+cpo_width/2
                        (when (IsLegalCPO CV x0 y0 x1 y1 nil)
                          todraw = (cons (list x0:y0 x1:y1) todraw)
                          )
                        )
               )
         )

    ; draw CPOs
    cpos = (DrawCPORects CV todraw)
    todraw = nil

    ; draw PO block at left and right edges where necessary
    (for y 0 rows-1
         ya = cy0+(y+0.5)*poly_pitch
         y0 = ya-poly_width/2
         y1 = ya+poly_width/2
         (when (NumberOfOverlaps CV (list "PO" "drawing") cx0 y0 cx1 y1 0 0)>0
               poly_locs = (FindCPOLocationsFromPoly CV2 cx0 ya cx1 ya 0)
               x0 = (car poly_locs)
               x1 = (car (last poly_locs))
               (when (and x0-cx0 < max_edge x0-cx0 >= min_edge)
                 obj = (dbCreateRect CV (list "PO" "block") (list cx0-overhang:y0 x0:y1))
                 (SetGridPolyProp obj)
                 block_shapes = (cons obj block_shapes)
                 )
               (when (and cx1-x1 < max_edge cx1-x1 >= min_edge)
                 obj = (dbCreateRect CV (list "PO" "block") (list x1:y0 cx1+overhang:y1))
                 (SetGridPolyProp obj)
                 block_shapes = (cons obj block_shapes)
                 )
               )
         )

    ; redraw grid poly avoiding blockages
    (leLayerAndNot CV (list "PO" "grd") (list "PO" "block") Scratch2LPP)
    (leLayerAndNot CV Scratch2LPP (list "PO" "dummy1") Scratch1LPP)
    (foreach obj grid_poly (dbDeleteObject obj))
    (foreach obj block_shapes (dbDeleteObject obj))

    ; delete short grid poly or keep it
    (foreach obj (setof s CV->shapes s->lpp==Scratch1LPP)
             x0 = (car (car  obj->bBox))
             x1 = (car (cadr obj->bBox))
             (cond (x1-x0<min_po_length (dbDeleteObject obj))
                   (t obj->lpp=(list "PO" "grd")
                      (SetGridPolyProp obj))
                   )
             )
    (foreach obj (setof s CV->shapes s->lpp==Scratch2LPP) (dbDeleteObject obj))

    ; delete cpo_scratch view
    obj = (ddGetObj CV->libName CV->cellName "cpo_scratch")
    (when obj (ddDeleteObj obj))

    ; set version and save
    (SetGridPolyVersion CV)
    (dbSave CV)
    )
  t
  )

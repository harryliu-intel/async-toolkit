//------------------------------------------------------------------------------
//
//  INTEL CONFIDENTIAL
//
//  Copyright 2006 - 2015 Intel Corporation All Rights Reserved.
//
//  The source code contained or described herein and all documents related
//  to the source code ("Material") are owned by Intel Corporation or its
//  suppliers or licensors. Title to the Material remains with Intel
//  Corporation or its suppliers and licensors. The Material contains trade
//  secrets and proprietary and confidential information of Intel or its
//  suppliers and licensors. The Material is protected by worldwide copyright
//  and trade secret laws and treaty provisions. No part of the Material may
//  be used, copied, reproduced, modified, published, uploaded, posted,
//  transmitted, distributed, or disclosed in any way without Intel's prior
//  express written permission.
//
//  No license under any patent, copyright, trade secret or other intellectual
//  property right is granted to or conferred upon you by disclosure or
//  delivery of the Materials, either expressly, by implication, inducement,
//  estoppel or otherwise. Any license under such intellectual property rights
//  must be express and approved by Intel in writing.
//
//------------------------------------------------------------------------------
//------------------------------------------------------------------------------
// -- Authors      : Chihjen Chang
// -- Project Name : EPL IP for MST
// -- Description  : This is RDL for the MAC block.
//------------------------------------------------------------------------------

`include "lib_udp.rdl"
<% use security; %>
<% my %Security_Props = security::GetSecurityInfo(); %>


//------------------------------------------------------------------------------
// Enumerations

enum mac_timescale_enum {
  T_100NS = 3'd0 { desc = "100 ns"; };
  T_1US   = 3'd1 { desc = "1 us"; };
  T_10US  = 3'd2 { desc = "10 us"; };
  T_100US = 3'd3 { desc = "100 us"; };
  T_1MS   = 3'd4 { desc = "1 ms"; };
  T_10MS  = 3'd5 { desc = "10 ms"; };
  T_100MS = 3'd6 { desc = "100 ms"; };
  T_1S    = 3'd7 { desc = "1 s"; };
};

enum mac_link_fault_enum {
  OK = 2'd0 { desc = "No fault condition reported"; };
  LF = 2'd1 { desc = "Local Fault"; };
  RF = 2'd2 { desc = "Remote Fault"; };
  LI = 2'd3 { desc = "Link Interruption"; };
};

enum mac_control_mode_enum {
  NONE  = 2'd0 { desc = "No flow control"; };
  PAUSE = 2'd1 { desc = "802.3 Pause flow control"; };
  PFC   = 2'd2 { desc = "802.1 PFC flow control"; };
};

enum mac_fault_mode_enum {
  NORMAL      = 3'd0 { desc = "Tx MII controlled by Figure 46-9: Link Fault Signaling State Diagram"; };
  FORCE_IDLE  = 3'd1 { desc = "Force Idle on Tx MII"; };
  FORCE_LF    = 3'd2 { desc = "Force Local Fault on Tx MII"; };
  FORCE_RF    = 3'd3 { desc = "Force Remote Fault on Tx MII"; };
  FORCE_LI    = 3'd4 { desc = "Force Link Interruption"; };
  IGNORE      = 3'd5 { desc = "Ignore Rx link_fault, send normal traffic on Tx MII"; };
  FORCE_ERROR = 3'd6 { desc = "Force Errors on Tx MII"; };
  FORCE_USER  = 3'd7 { desc = "Force User Value on Tx MII"; };
};

enum mac_parse_event_enum {
  IPV4   = 3'd0 { desc = "IPv4"; };
  IPV6   = 3'd1 { desc = "IPv6"; };
  MPLS_U = 3'd2 { desc = "MPLS unicast"; };
  MPLS_M = 3'd3 { desc = "MPLS multicast"; };
  VLAN1  = 3'd4 { desc = "VLAN1"; };
  VLAN2  = 3'd5 { desc = "VLAN2"; };
};

enum mac_parse_ethertype_enum {
  UNUSED = 2'd0 { desc = "Unused"; };
  VLAN   = 2'd1 { desc = "VLAN"; };
  MPLS   = 2'd2 { desc = "MPLS"; };
  IP     = 2'd3 { desc = "IP"; };
};

enum mac_parse_precedence_enum {
  VLAN   = 2'd0 { desc = "VLAN"; };
  MPLS   = 2'd1 { desc = "MPLS"; };
  IP     = 2'd2 { desc = "IP"; };
  META   = 2'd3 { desc = "META"; };
};

enum mac_onpi_speed_enum {
  S_1G   = 8'd2   { desc = "1 Gbps";   };
  S_2P5G = 8'd2   { desc = "2.5 Gbps"; };
  S_5G   = 8'd4   { desc = "5 Gbps";   };
  S_10G  = 8'd5   { desc = "10 Gbps";  };
  S_25G  = 8'd7   { desc = "25 Gbps";  };
  S_50G  = 8'd9   { desc = "50 Gbps";  };
  S_100G = 8'd26  { desc = "100 Gbps"; };
  S_200G = 8'd43  { desc = "200 Gbps"; };
};


//------------------------------------------------------------------------------
// MAC_IP

reg mac_ip_r {
  Security_PolicyGroup     = <%=$Security_Props{'MBY_PG1'}%>;
  Security_ReadAccess_Str  = <%=$Security_Props{'MBY_PG1_RAC_AGENTS'}%>;
  Security_WriteAccess_Str = <%=$Security_Props{'MBY_PG1_WAC_AGENTS'}%>;
  shared;
  HandCoded = true;
  name = "MAC Interrupt Pending";
  desc = "For each bit in this register, the associated interrupt has been triggered if the bit is 1,
          and has not been triggered if the bit is 0.  Each bit contributes to the MAC interrupt unless
          it is masked by the corresponding bit in the MAC Interrupt Mask Register.";
  regwidth = 64;
  accesswidth = 64;
  //DefaultValRTLSignal = "u_epl_mac_apr_func_logic.u_epl_mac.u_mac_wrp_mgmt.u_mac_mgmt.u_interrupt.ip_q";
  
  field {
    AccessType = "RW/1C/V";
    desc = "Flow Control Attention. The PAUSE/PFC flow control signal has been asserted over an extended period of
    time greater than the programmable time threshold.";
    ValRandomize = true;
  } FLOW_CONTROL_ATTN[34:34] = 1'h0;  
  field {
    AccessType = "RW/1C/V";
    desc = "Triggered when an internal memory detects ECC uncorrectable error.";
    ValRandomize = true;
  } MEMORY_UERR[33:33] = 1'h0;  
  field {
    AccessType = "RW/1C/V";
    desc = "Triggered when an internal memory detects ECC correctable error.";
    ValRandomize = true;
  } MEMORY_CERR[32:32] = 1'h0;
  field {
    AccessType = "RW/1C/V";
    desc = "Triggered when Rx MAC receives a PFC/PAUSE packet.";
    ValRandomize = true;
  } RX_PFC_PAUSE[31:31] = 1'h0;  
  field {
    AccessType = "RW/1C/V";
    desc = "Triggered when an invalid ONPI speed is selected in either master or slave mode.";
    ValRandomize = true;
  } INVALID_SPEED[30:30] = 1'h0;
  field {
    AccessType = "RW/1C/V";
    desc = "Triggered on the MAC parser performing a priority encode of an IPv4 packet.";
    ValRandomize = true;
  } PRI_ENC_IPV4[29:29] = 1'h0;
  field {
    AccessType = "RW/1C/V";
    desc = "Triggered on the MAC parser performing a priority encode of an IPv6 packet.";
    ValRandomize = true;
  } PRI_ENC_IPV6[28:28] = 1'h0;
  field {
    AccessType = "RW/1C/V";
    desc = "Triggered on the MAC parser performing a priority encode of an MPLS1 (unicast) packet.";
    ValRandomize = true;
  } PRI_ENC_MPLS1[27:27] = 1'h0;
  field {
    AccessType = "RW/1C/V";
    desc = "Triggered on the MAC parser performing a priority encode of an MPLS2 (multicast) packet.";
    ValRandomize = true;
  } PRI_ENC_MPLS2[26:26] = 1'h0;
  field {
    AccessType = "RW/1C/V";
    desc = "Triggered on the MAC parser performing a priority encode of a VLAN1 packet.";
    ValRandomize = true;
  } PRI_ENC_VLAN1[25:25] = 1'h0;
  field {
    AccessType = "RW/1C/V";
    desc = "Triggered on the MAC parser performing a priority encode of a VLAN2 packet.";
    ValRandomize = true;
  } PRI_ENC_VLAN2[24:24] = 1'h0;
  field {
    AccessType = "RW/1C/V";
    desc = "Triggered on a debounced change of Link Fault status.";
    ValRandomize = true;
  } LINK_FAULT_DEBOUNCED[23:23] = 1'h0;
  field {
    AccessType = "RW/1C/V";
    desc = "Triggered on a change of Link Fault status.";
    ValRandomize = true;
  } LINK_FAULT_CHANGE[22:22] = 1'h0;
  field {
    AccessType = "RW/1C/V";
    desc = "Triggered on a change of MAC_STATUS.LPI_RX.";
    ValRandomize = true;
  } LPI_RX[21:21] = 1'h0;
  field {
    AccessType = "RW/1C/V";
    desc = "Triggered on a change of Receive Link Up.";
    ValRandomize = true;
  } RX_LINK_UP[20:20] = 1'h0;
  field {
    AccessType = "RW/1C/V";
    desc = "Triggered on every transmitted frame.";
    ValRandomize = true;
  } TX_FRAME[19:19] = 1'h0;
  field {
    AccessType = "RW/1C/V";
    desc = "Triggered on every received frame.";
    ValRandomize = true;
  } RX_FRAME[18:18] = 1'h0;
  field {
    AccessType = "RW/1C/V";
    desc = "Triggered on reception of either a Sequence ordered_set or a Signal ordered_set.  The most
            recently received Sequence or Signal ordered_set is available in the MAC_RX_SEQUENCE register.";
    ValRandomize = true;
  } RX_SEQ_OR_SIG[17:17] = 1'h0;
  field {
    AccessType = "RW/1C/V";
    desc = "Trigered on reception of a bad preamble.";
    ValRandomize = true;
  } ERROR_RX_PREAMBLE[16:16] = 1'h0;
  field {
    AccessType = "RW/1C/V";
    desc = "Triggered on reception of an error code.";
    ValRandomize = true;
  } ERROR_RX_CODE[15:15] = 1'h0;
  field {
    AccessType = "RW/1C/V";
    desc = "Triggered when a frame is terminated with a code error and the frame is not a runt or jabber.";
    ValRandomize = true;
  } ERROR_RX_FRAME[14:14] = 1'h0;
  field {
    AccessType = "RW/1C/V";
    desc = "Triggered on reception of an otherwise good frame with a bad FCS.";
    ValRandomize = true;
  } ERROR_RX_FCS[13:13] = 1'h0;
  field {
    AccessType = "RW/1C/V";
    desc = "Triggered on reception of a long frame with a good FCS.";
    ValRandomize = true;
  } ERROR_RX_OVERSIZE[12:12] = 1'h0;
  field {
    AccessType = "RW/1C/V";
    desc = "Triggered on reception of a long frame with a bad FCS.";
    ValRandomize = true;
  } ERROR_RX_JABBER[11:11] = 1'h0;
  field {
    AccessType = "RW/1C/V";
    desc = "Triggered on reception of a short frame with a good FCS.";
    ValRandomize = true;
  } ERROR_RX_UNDERSIZE[10:10] = 1'h0;
  field {
    AccessType = "RW/1C/V";
    desc = "Triggered on reception of a short frame with a bad FCS.";
    ValRandomize = true;
  } ERROR_RX_RUNT[9:9] = 1'h0;
  field {
    AccessType = "RW/1C/V";
    desc = "Triggered on a receive overrun condition, indicating switch fabric congestion.";
    ValRandomize = true;
  } ERROR_RX_OVERRUN[8:8] = 1'h0;
  field {
    AccessType = "RW/1C/V";
    desc = "Triggered when a transmitted frame has an unexpected FCS (good when expecting bad, or bad when expecting good) checked near the switch interface.";
    ValRandomize = true;
  } ERROR_TX_DATA_CORRUPT[7:7] = 1'h0;
  field {
    AccessType = "RW/1C/V";
    desc = "Triggered when a transmitted frame has a bad FCS checked near the MII interface.";
    ValRandomize = true;
  } ERROR_TX_FCS[6:6] = 1'h0;
  field {
    AccessType = "RW/1C/V";
    desc = "Triggered on a transmit underrun condition, indicating switch fabric congestion.";
    ValRandomize = true;
  } ERROR_TX_UNDERRUN[5:5] = 1'h0;
  field {
    AccessType = "RW/1C/V";
    desc = "Triggered on a change of MAC_STATUS.LPI_SILENT.";
    ValRandomize = true;
  } LPI_SILENT[4:4] = 1'h0;
  field {
    AccessType = "RW/1C/V";
    desc = "Triggered on transmission of an internally generated MAC control frame.";
    ValRandomize = true;
  } CONTROL_FRAME_SENT[3:3] = 1'h0;
  field {
    AccessType = "RW/1C/V";
    desc = "Triggered when the state of congestion has changed, requiring 802.3 Pause frame transmission.";
    ValRandomize = true;
  } PAUSE_CONGESTION[2:2] = 1'h0;
  field {
    AccessType = "RW/1C/V";
    desc = "Triggered when the state of congestion has changed, requiring 802.1 Priority Flow Control frame transmission.";
    ValRandomize = true;
  } PFC_CONGESTION[1:1] = 1'h0;
  field {
    AccessType = "RW/1C/V";
    desc = "Triggered on completion of a statistics snapshot request.
            This bit must be cleared before another snapshot request can be serviced.";
    ValRandomize = true;
  } STATS_READY[0:0] = 1'h0;
}; // mac_ip_r


//------------------------------------------------------------------------------
// MAC_IM

reg mac_im_r {
  Security_PolicyGroup     = <%=$Security_Props{'MBY_PG1'}%>;
  Security_ReadAccess_Str  = <%=$Security_Props{'MBY_PG1_RAC_AGENTS'}%>;
  Security_WriteAccess_Str = <%=$Security_Props{'MBY_PG1_WAC_AGENTS'}%>;
  shared;
  HandCoded = true;
  name = "MAC Interrupt Mask";
  desc = "The interrupt mask register controls if the corresponding interrupt
          source is presented to the interrupt hierarchy (bit is set to 0) or
          masked out (bit is set to 1).";
  regwidth = 64;
  accesswidth = 64;
  //DefaultValRTLSignal = "u_epl_mac_apr_func_logic.u_epl_mac.u_mac_wrp_mgmt.u_mac_mgmt.u_interrupt.im_q";

  field {
    AccessType = "RW";
    desc = "Flow Control Attention. The PAUSE/PFC flow control signal has been asserted over an extended period of
    time greater than the programmable time threshold.";
    ValRandomize = true;
  } FLOW_CONTROL_ATTN[34:34] = 1'h0;  
  field {
    AccessType = "RW";
    desc = "Triggered when an internal memory detects ECC uncorrectable error.";
    ValRandomize = true;
  } MEMORY_UERR[33:33] = 1'h1;  
  field {
    AccessType = "RW";
    desc = "Triggered when an internal memory detects ECC correctable error.";
    ValRandomize = true;
  } MEMORY_CERR[32:32] = 1'h1;
  field {
    AccessType = "RW";
    desc = "Triggered when Rx MAC receives a PFC/PAUSE packet.";
    ValRandomize = true;
  } RX_PFC_PAUSE[31:31] = 1'h1;  
  field {
    AccessType = "RW";
    desc = "Triggered when an invalid ONPI speed is selected in either master or slave mode.";
    ValRandomize = true;
  } INVALID_SPEED[30:30] = 1'h1;
  field {
    AccessType = "RW";
    desc = "Triggered on the MAC parser performing a priority encode of an IPv4 packet.";
    ValRandomize = true;
  } PRI_ENC_IPV4[29:29] = 1'h1;
  field {
    AccessType = "RW";
    desc = "Triggered on the MAC parser performing a priority encode of an IPv6 packet.";
    ValRandomize = true;
  } PRI_ENC_IPV6[28:28] = 1'h1;
  field {
    AccessType = "RW";
    desc = "Triggered on the MAC parser performing a priority encode of an MPLS1 (unicast) packet.";
    ValRandomize = true;
  } PRI_ENC_MPLS1[27:27] = 1'h1;
  field {
    AccessType = "RW";
    desc = "Triggered on the MAC parser performing a priority encode of an MPLS2 (multicast) packet.";
    ValRandomize = true;
  } PRI_ENC_MPLS2[26:26] = 1'h1;
  field {
    AccessType = "RW";
    desc = "Triggered on the MAC parser performing a priority encode of a VLAN1 packet.";
    ValRandomize = true;
  } PRI_ENC_VLAN1[25:25] = 1'h1;
  field {
    AccessType = "RW";
    desc = "Triggered on the MAC parser performing a priority encode of a VLAN2 packet.";
    ValRandomize = true;
  } PRI_ENC_VLAN2[24:24] = 1'h1;
  field {
    AccessType = "RW";
    desc = "Triggered on a debounced change of Link Fault status.";
    ValRandomize = true;
  } LINK_FAULT_DEBOUNCED[23:23] = 1'h1;
  field {
    AccessType = "RW";
    desc = "Triggered on a change of Link Fault status.";
    ValRandomize = true;
  } LINK_FAULT_CHANGE[22:22] = 1'h1;
  field {
    AccessType = "RW";
    desc = "Triggered on a change of MAC_STATUS.LPI_RX.";
    ValRandomize = true;
  } LPI_RX[21:21] = 1'h1;
  field {
    AccessType = "RW";
    desc = "Triggered on a change of Receive Link Up.";
    ValRandomize = true;
  } RX_LINK_UP[20:20] = 1'h1;
  field {
    AccessType = "RW";
    desc = "Triggered on every transmitted frame.";
    ValRandomize = true;
  } TX_FRAME[19:19] = 1'h1;
  field {
    AccessType = "RW";
    desc = "Triggered on every received frame.";
    ValRandomize = true;
  } RX_FRAME[18:18] = 1'h1;
  field {
    AccessType = "RW";
    desc = "Triggered on reception of either a Sequence ordered_set or a Signal ordered_set.  The most
            recently received Sequence or Signal ordered_set is available in the MAC_RX_SEQUENCE register.";
    ValRandomize = true;
  } RX_SEQ_OR_SIG[17:17] = 1'h1;
  field {
    AccessType = "RW";
    desc = "Trigered on reception of a bad preamble.";
    ValRandomize = true;
  } ERROR_RX_PREAMBLE[16:16] = 1'h1;
  field {
    AccessType = "RW";
    desc = "Triggered on reception of an error code.";
    ValRandomize = true;
  } ERROR_RX_CODE[15:15] = 1'h1;
  field {
    AccessType = "RW";
    desc = "Triggered when a frame is terminated with a code error and the frame is not a runt or jabber.";
    ValRandomize = true;
  } ERROR_RX_FRAME[14:14] = 1'h1;
  field {
    AccessType = "RW";
    desc = "Triggered on reception of an otherwise good frame with a bad FCS.";
    ValRandomize = true;
  } ERROR_RX_FCS[13:13] = 1'h1;
  field {
    AccessType = "RW";
    desc = "Triggered on reception of a long frame with a good FCS.";
    ValRandomize = true;
  } ERROR_RX_OVERSIZE[12:12] = 1'h1;
  field {
    AccessType = "RW";
    desc = "Triggered on reception of a long frame with a bad FCS.";
    ValRandomize = true;
  } ERROR_RX_JABBER[11:11] = 1'h1;
  field {
    AccessType = "RW";
    desc = "Triggered on reception of a short frame with a good FCS.";
    ValRandomize = true;
  } ERROR_RX_UNDERSIZE[10:10] = 1'h1;
  field {
    AccessType = "RW";
    desc = "Triggered on reception of a short frame with a bad FCS.";
    ValRandomize = true;
  } ERROR_RX_RUNT[9:9] = 1'h1;
  field {
    AccessType = "RW";
    desc = "Triggered on a receive overrun condition, indicating switch fabric congestion.";
    ValRandomize = true;
  } ERROR_RX_OVERRUN[8:8] = 1'h1;
  field {
    AccessType = "RW";
    desc = "Triggered when a transmitted frame has an unexpected FCS (good when expecting bad, or bad when expecting good) checked near the switch interface.";
    ValRandomize = true;
  } ERROR_TX_DATA_CORRUPT[7:7] = 1'h1;
  field {
    AccessType = "RW";
    desc = "Triggered when a transmitted frame has a bad FCS checked near the MII interface.";
    ValRandomize = true;
  } ERROR_TX_FCS[6:6] = 1'h1;
  field {
    AccessType = "RW";
    desc = "Triggered on a transmit underrun condition, indicating switch fabric congestion.";
    ValRandomize = true;
  } ERROR_TX_UNDERRUN[5:5] = 1'h1;
  field {
    AccessType = "RW";
    desc = "Triggered on a change of MAC_STATUS.LPI_SILENT.";
    ValRandomize = true;
  } LPI_SILENT[4:4] = 1'h1;
  field {
    AccessType = "RW";
    desc = "Triggered on transmission of an internally generated MAC control frame.";
    ValRandomize = true;
  } CONTROL_FRAME_SENT[3:3] = 1'h1;
  field {
    AccessType = "RW";
    desc = "Triggered when the state of congestion has changed, requiring 802.3 Pause frame transmission.";
    ValRandomize = true;
  } PAUSE_CONGESTION[2:2] = 1'h1;
  field {
    AccessType = "RW";
    desc = "Triggered when the state of congestion has changed, requiring 802.1 Priority Flow Control frame transmission.";
    ValRandomize = true;
  } PFC_CONGESTION[1:1] = 1'h1;
  field {
    AccessType = "RW";
    desc = "Triggered on completion of a statistics snapshot request.
            This bit must be cleared before another snapshot request can be serviced.";
    ValRandomize = true;
  } STATS_READY[0:0] = 1'h1;
}; // mac_im_r

// ============================ mac_scratch_r (width=64, linecache=0) =======================

reg mac_scratch_r {
  Security_PolicyGroup     = <%=$Security_Props{'MBY_PG1'}%>;
  Security_ReadAccess_Str  = <%=$Security_Props{'MBY_PG1_RAC_AGENTS'}%>;
  Security_WriteAccess_Str = <%=$Security_Props{'MBY_PG1_WAC_AGENTS'}%>;
  shared;
  HandCoded = false;
  name = "MAC Scratch Register.";
  desc = "Scratch Pad";

  regwidth    = 64; 
  accesswidth = 64; 
  DefaultValRTLSignal = "u_epl_mac_apr_func_logic.u_epl_mac.u_mac_wrp_mgmt.u_mac_mgmt.%reg_name%_q.%field_name%";

  field {
    AccessType = "RW";
    desc = " Scratch pad data.";
    ValRandomize = true;
  } DATA[63:0] = 64'h0;
};

//------------------------------------------------------------------------------
// MAC_DA_ADDRESS [0..4]

reg mac_da_address_r {
  Security_PolicyGroup     = <%=$Security_Props{'MBY_PG1'}%>;
  Security_ReadAccess_Str  = <%=$Security_Props{'MBY_PG1_RAC_AGENTS'}%>;
  Security_WriteAccess_Str = <%=$Security_Props{'MBY_PG1_WAC_AGENTS'}%>;
  shared;
  HandCoded = true;
  name = "MAC Destination Address per PF";
  desc = "MAC Destination MAC Address Register used for WoL and RoL, each port 
          supports up to 5 PFs";
  regwidth = 64;
  accesswidth = 64;
  DefaultValRTLSignal = "u_epl_mac_apr_func_logic.u_epl_mac.u_mac_wrp_mgmt.u_mac_mgmt.%reg_name%_q.%field_name%";
  field {
    AccessType = "RW";
    desc = "
           MAC Destination Address valid, set by software when the Destination is programmed.
           ";
    ValRandomize = true;
  } DEST_ADDRESS_VAL[48:48] = 1'h0;  
  field {
    AccessType = "RW";
    desc = "
           MAC Destination Address for WoL and RoL magic packet filtering
           ";
    ValRandomize = true;
  } DEST_ADDRESS[47:0] = 48'h0;  
}; // mac_da_address_r



//------------------------------------------------------------------------------
// MAC_MAGIC_PKT_FILTER_CFG

reg mac_magic_pkt_filter_cfg_r {
  Security_PolicyGroup     = <%=$Security_Props{'MBY_PG1'}%>;
  Security_ReadAccess_Str  = <%=$Security_Props{'MBY_PG1_RAC_AGENTS'}%>;
  Security_WriteAccess_Str = <%=$Security_Props{'MBY_PG1_WAC_AGENTS'}%>;
  shared;
  HandCoded = true;
  name = "MAC WoL Config";
  desc = "MAC WoL Config";
  regwidth = 64;
  accesswidth = 64;
  DefaultValRTLSignal = "u_epl_mac_apr_func_logic.u_epl_mac.u_mac_wrp_mgmt.u_mac_mgmt.%reg_name%_q.%field_name%";
  field {
    AccessType = "RW";
    desc = "
           Sync Pattern to look for in magic packet packet
           ";
    ValRandomize = true;
  } SYNC_PATTERN[10:3] = 8'hFF;  
  field {
    AccessType = "RW";
    desc = "
           Multicast Address is allowed for magic packet filtering
           ";
    ValRandomize = true;
  } MC_ALLOW[2:2] = 1'h0;   
  field {
    AccessType = "RW";
    desc = "
           Broadcast Address is allowed for magic packet filtering
           ";
    ValRandomize = true;
  } BC_ALLOW[1:1] = 1'h0;   
  field {
    AccessType = "RW";
    desc = "
           Magic Packet Filtering Enable
           ";
    ValRandomize = true;
  } MAGIC_PKT_FILTER_ENABLE[0:0] = 1'h0;  
}; // mac_magic_pkt_filter_cfg_r

//------------------------------------------------------------------------------
// MAC_CFG

reg mac_cfg_r {
  Security_PolicyGroup     = <%=$Security_Props{'MBY_PG1'}%>;
  Security_ReadAccess_Str  = <%=$Security_Props{'MBY_PG1_RAC_AGENTS'}%>;
  Security_WriteAccess_Str = <%=$Security_Props{'MBY_PG1_WAC_AGENTS'}%>;
  shared;
  HandCoded = true;
  name = "MAC Configuration";
  desc = "MAC Configuration Register";
  regwidth = 64;
  accesswidth = 64;
  DefaultValRTLSignal = "u_epl_mac_apr_func_logic.u_epl_mac.u_mac_wrp_mgmt.u_mac_mgmt.%reg_name%_q.%field_name%";
  field {
    AccessType = "RW";
    desc = "Rx Packet FCS Stripping Enable
            * (0) Keep FCS for all Rx packet.
	    * (1) Strip FCS for all Rx packets.";
    ValRandomize = true;
  } RX_STRIP_FCS_EN[38:38] = 1'h0;
  field {
    AccessType = "RW";
    desc = "Pause Recepation Flow Control Mode
            * (0) Assert all 8 XOFF signals to upper layer
	    * (1) Stop Transmit on at the next packet boundary";
    ValRandomize = true;
  } RX_PAUSE_MODE[37:37] = 1'h0;
  field {
    AccessType = "RW";
    desc = "Port ID associated with the MAC";
    ValRandomize = true;
  } PORT_ID[36:33] = 4'h0;
  field {
    AccessType = "RW";
    desc = "Ignore the LPI receive state (MAC_STATUS.LPI_RX) when reporting MAC_STATUS.LINK_STATUS.
            * (0) link_status is low if LPI_RX is high
            * (1) link_status does not depend on LPI_RX";
    ValRandomize = true;
  } LINK_STATUS_IGNORE_LPI[32:32] = 1'h0;
  field {
    AccessType = "RW";
    desc = "Amount of time to wait after transmitting or receiving any frame before
            deasserting the activity signal to the management interface.  Default value is 1 ms
            coded as 1000 us for better accuracy.
            Units are specified in ACTIVITY_TIMESCALE.  Accuracy is 0/+1 unit.";
    ValRandomize = true;
  } ACTIVITY_TIMEOUT[31:22] = 10'h3e8;
  field {
    encode = mac_timescale_enum;
    AccessType = "RW";
    desc = "Units for ACTIVITY_TIMEOUT:
            * (0) 100 ns
            * (1) 1 us
            * (2) 10 us
            * (3) 100 us
            * (4) 1 ms
            * (5) 10 ms
            * (6) 100 ms
            * (7) 1 s";
    ValRandomize = true;
  } ACTIVITY_TIMESCALE[21:19] = 3'h1;
  field {
    AccessType = "RW";
    desc = "Enable use of the direct hardware based linkup signal in combination with
            MAC_PIA_CFG.ONPI_ENABLE to control ONPI linkup signalling.
            * (0) Disable the hardware based linkup signal
            * (1) Enable the hardware based linkup signal";
    ValRandomize = true;
  } MAC_LINKUP_ENABLE[18:18] = 1'h0;
  field {
    AccessType = "RW";
    desc = "* (0) Do not clear statistics counters
            * (1) Clear statistics when the snapshot is captured";
    ValRandomize = true;
  } STATS_CLR_ON_SNAP[17:17] = 1'h0;
  field {
    AccessType = "RW";
    desc = "A 0 to 1 transition requests stats registers for this port.";
    ValRandomize = true;
  } STATS_REQUEST[16:16] = 1'h0;
  field {
    encode = mac_control_mode_enum;
    AccessType = "RW";
    desc = "* (0) Flow control Disabled
            * (1) Pause Flow Control Enabled
            * (2) Priority Flow Control Enabled";
    ValRandomize = true;
  } MAC_CONTROL_MODE[15:14] = 2'h0;
  field {
    AccessType = "RW";
    desc = "Maximum frame length allowed through the MAC data path, in bytes.  Frames longer than
            max_frame_length are truncated to max_frame_length plus 1-7 bytes.";
    ValRandomize = true;
  } MAX_FRAME_LENGTH[13:0] = 14'h2800;  // 10,240 bytes
}; // mac_cfg_r


//------------------------------------------------------------------------------
// MAC_PATH_CFG

reg mac_path_cfg_r {
  Security_PolicyGroup     = <%=$Security_Props{'MBY_PG3'}%>;
  Security_ReadAccess_Str  = <%=$Security_Props{'MBY_PG3_RAC_AGENTS'}%>;
  Security_WriteAccess_Str = <%=$Security_Props{'MBY_PG3_WAC_AGENTS'}%>;
  shared;
  HandCoded = true;
  name = "MAC Path Configuration";
  desc = "MAC Path Configuration Register";
  regwidth = 64;
  accesswidth = 64;
  DefaultValRTLSignal = "u_epl_mac_apr_func_logic.u_epl_mac.u_mac_wrp_mgmt.u_mac_mgmt.%reg_name%_q.%field_name%";
  field {
    AccessType = "RW";
    desc = "Enable RX DRAIN when SWITCH_LOOPBACK=1 to prevent propagating Rx packet back to the network if
    the intention is to enable the internal MII loopback from Tx MAC to Rx MAC";
    ValRandomize = true;
  } FLOOP_RX_DRAIN[21:21] = 1'h0;
  field {
    AccessType = "RW";
    desc = "Enable Tx IDLE insertion when MII_LOOPBACK=1 to prevent propagating Tx packet back to the Fabric if
    the intention is to enable the internal Fabric loopback from Rx MAC to Tx MAC";
    ValRandomize = true;
  } MLOOP_TX_IDLE[20:20] = 1'h0;
  field {
    AccessType = "RW";
    desc = "Pause Frame ONPI Type";
    ValRandomize = true;
  } PAUSE_PFC_ONPI_TYPE[19:4] = 16'h0;
  field {
    AccessType = "RW";
    desc = "* (0) Disable and bypass MACsec Layer
            * (1) Enable MACsec Layer";
    ValRandomize = true;
  } MSEC_ENABLE[3:3] = 1'h0;
  field {
    AccessType = "RW";
    desc = "Disable packet processing in order to safely change msec_enable.
            * (0) Normal operation
            * (1) Stop packet processing at a frame boundary";
    ValRandomize = true;
  } MSEC_HOLD[2:2] = 1'h0;
  field {
    AccessType = "RW";
    desc = "MAC MII interface bi-directional loopback, between MAC and PIA
            * (0) Loopback disabled
            * (1) Loopback enabled";
    ValRandomize = true;
  } MII_LOOPBACK[1:1] = 1'h0;
  field {
    AccessType = "RW";
    desc = "MAC switch interface bi-directional loopback, between MAC and PB
            * (0) Loopback disabled
            * (1) Loopback enabled";
    ValRandomize = true;
  } SWITCH_LOOPBACK[0:0] = 1'h0;
}; // mac_path_cfg_r


//------------------------------------------------------------------------------
// MAC_STATUS

reg mac_status_r {
  Security_PolicyGroup     = <%=$Security_Props{'MBY_PG1'}%>;
  Security_ReadAccess_Str  = <%=$Security_Props{'MBY_PG1_RAC_AGENTS'}%>;
  Security_WriteAccess_Str = <%=$Security_Props{'MBY_PG1_WAC_AGENTS'}%>;
  shared;
  HandCoded = true;
  name = "MAC Status";
  desc = "MAC Status Register";
  regwidth = 64;
  accesswidth = 64;
  DefaultValRTLSignal = "u_epl_mac_apr_func_logic.u_epl_mac.u_mac_wrp_mgmt.u_mac_mgmt.%reg_name%.%field_name%";
  field {
    AccessType = "RO/V";
    desc = "This bit is used in combination with MAC_PATH_CFG.MSEC_HOLD to know when it is safe to
            change MAC_PATH_CFG.MSEC_ENABLE.  After setting MAC_PATH_CFG.MSEC_HOLD, if MSEC_EMPTY is 1
            then there is no more data in the MSEC pipeline and it is safe to either enable or
            disable the MSEC path via MAC_PATH_CFG.MSEC_ENABLE.
            * (0) MSEC Tx and Rx pipelines are not empty
            * (1) MSEC Tx and Rx pipelines are empty";
    ValRandomize = true;
  } MSEC_EMPTY[17:17] = 1'h1;
  field {
    AccessType = "RO/V";
    desc = "* (0) not servicing a stats snapshot request for this MAC
            * (1) servicing a stats snapshot request for this MAC";
    ValRandomize = true;
  } STATS_IN_PROGRESS[16:16] = 1'h0;
  field {
    AccessType = "RO/V";
    desc = "* (0) stats not available
            * (1) stats available for this MAC
            This bit is cleared when MAC_IP.STATS_READY is cleared.";
    ValRandomize = true;
  } STATS_READY[15:15] = 1'h0;
  field {
    encode = mac_link_fault_enum;
    AccessType = "RO/V";
    desc = "This field is intended to be used by software for Link Fault status.
            The debounced Link Fault provides a filtered version of Link Fault which removes spurious transitions.
            * (0) OK
            * (1) Local Fault
            * (2) Remote Fault
            * (3) Link Interruption";
    ValRandomize = true;
  } LINK_FAULT_DEBOUNCED[14:13] = 2'h0;
  field {
    encode = mac_link_fault_enum;
    AccessType = "RO/V";
    desc = "This field indicates the hardware state.
            It depends on link_fault and link_fault_debounced,  and is used by MAC hardware to select appropriate
            packet handling and fault signaling.
            * (0) OK
            * (1) Local Fault
            * (2) Remote Fault
            * (3) Link Interruption";
    ValRandomize = true;
  } LINK_FAULT_MAC[12:11] = 2'h0;
  field {
    encode = mac_link_fault_enum;
    AccessType = "RO/V";
    desc = "Link Fault status as determined by the RS Link Fault state machine.
            * (0) OK
            * (1) Local Fault
            * (2) Remote Fault
            * (3) Link Interruption";
    ValRandomize = true;
  } LINK_FAULT[10:9] = 2'h0;
  field {
    AccessType = "RO/V";
    desc = "ONPI tx_link_up state being sent to the link partner.
            * (0) link down
            * (1) link up";
    ValRandomize = true;
  } TX_LINK_UP[8:8] = 1'h0;
  field {
    AccessType = "RO/V";
    desc = "ONPI rx_link_up state received from the link partner.
            * (0) link down
            * (1) link up";
    ValRandomize = true;
  } RX_LINK_UP[7:7] = 1'h0;
  field {
    AccessType = "RO/V";
    desc = "Transmit activity indication.
           * (0) no frame transmission since last read
           * (1) frame transmission since last read";
    ValRandomize = true;
  } TRANSMITTING[6:6] = 1'h0;
  field {
    AccessType = "RO/V";
    desc = "Receive activity indication.
            * (0) no frame reception since last read
            * (1) frame reception since last read";
    ValRandomize = true;
  } RECEIVING[5:5] = 1'h0;
  field {
    AccessType = "RO/V";
    desc = "Low Power Idle transmission indication.
            * (0) not transmitting Low Power Idle
            * (1) transmitting Low Power Idle";
    ValRandomize = true;
  } LPI_TX[4:4] = 1'h0;
  field {
    AccessType = "RO/V";
    desc = "Low Power Idle reception indication.
           * (0) not receiving Low Power Idle
           * (1) receiving Low Power Idle";
    ValRandomize = true;
  } LPI_RX[3:3] = 1'h0;
  field {
    AccessType = "RO/V";
    desc = "Timed transmit non-activity indication used by the Energy Efficient Ethernet function (timeout configurable via MAC_TX_MII_CFG.LPI_ACTIVITY fields).
           * (0) recent or pending transmit activity
           * (1) no recent or pending transmit activity";
    ValRandomize = true;
  } LPI_SILENT[2:2] = 1'h0;
  field {
    AccessType = "RO/V";
    desc = "Activity reported to the management module.  Activity is true if a valid frame was either transmitted or received within the last activity time period (timeout configurable via MAC_CFG.ACTIVITY fields).
           * (0) no activity
           * (1) recent activity";
    ValRandomize = true;
  } ACTIVITY[1:1] = 1'h0;
  field {
    AccessType = "RO/V";
    desc = "Link status reported to the management module.  The link is up if both rx_link_up and tx_link_up are true, and if link_fault_mac is OK.
           * (0) link down
           * (1) link up";
    ValRandomize = true;
  } LINK_STATUS[0:0] = 1'h0;
}; // mac_status_r


//------------------------------------------------------------------------------
// MAC_SA

reg mac_sa_r {
  Security_PolicyGroup     = <%=$Security_Props{'MBY_PG1'}%>;
  Security_ReadAccess_Str  = <%=$Security_Props{'MBY_PG1_RAC_AGENTS'}%>;
  Security_WriteAccess_Str = <%=$Security_Props{'MBY_PG1_WAC_AGENTS'}%>;
  shared;
  HandCoded = true;
  name = "MAC Station Address";
  desc = "MAC Station Address Register";
  regwidth = 64;
  accesswidth = 64;
  DefaultValRTLSignal = "u_epl_mac_apr_func_logic.u_epl_mac.u_mac_wrp_mgmt.u_mac_mgmt.%reg_name%_q.%field_name%";
  field {
    AccessType = "RW";
    desc = "Physical address used for MAC Control frames.";
    ValRandomize = true;
  } PHYS_ADDRESS[47:0] = 48'h0;
}; // mac_sa_r

//------------------------------------------------------------------------------
// MAC_PAUSE_TIME_BASE

reg mac_pause_time_base_r {
  Security_PolicyGroup     = <%=$Security_Props{'MBY_PG1'}%>;
  Security_ReadAccess_Str  = <%=$Security_Props{'MBY_PG1_RAC_AGENTS'}%>;
  Security_WriteAccess_Str = <%=$Security_Props{'MBY_PG1_WAC_AGENTS'}%>;
  shared;
  HandCoded = true;
  name = "MAC Pause and PFC Time Base Register";
  desc = "MAC Pause and PFC Time Base Register";
  regwidth = 64;
  accesswidth = 64;
  DefaultValRTLSignal = "u_epl_mac_apr_func_logic.u_epl_mac.u_mac_wrp_mgmt.u_mac_mgmt.%reg_name%_q.%field_name%";
  field {
    AccessType = "RW";
    desc = "Tx Pause/PFC Time base.  Valid values from 0 to 16, The programmed value indicates to the
            hardware in suppression of one clock pulse out of the programmed value of cycles for the Pause
	    timer count down logic according to the port rate.";
    ValRandomize = true;
  } TX_TIME_BASE[12:8] = 5'h0;
  field {
    AccessType = "RW";
    desc = "Rx Pause/PFC Time base.  Valid values from 0 to 16, The programmed value indicates to the
            hardware in suppression of one clock pulse out of the programmed value of cycles for the Pause
	    timer count down logic according to the port rate.";
    ValRandomize = true;
  } RX_TIME_BASE[4:0] = 5'h0;
}; // mac_pause_time_base_r


//------------------------------------------------------------------------------
// MAC_TX_MII_CFG

reg mac_tx_mii_cfg_r {
  Security_PolicyGroup     = <%=$Security_Props{'MBY_PG1'}%>;
  Security_ReadAccess_Str  = <%=$Security_Props{'MBY_PG1_RAC_AGENTS'}%>;
  Security_WriteAccess_Str = <%=$Security_Props{'MBY_PG1_WAC_AGENTS'}%>;
  shared;
  HandCoded = true;
  name = "MAC transmit MII configuration";
  desc = "MAC transmit MII configuration Register";
  regwidth = 64;
  accesswidth = 64;
  DefaultValRTLSignal = "u_epl_mac_apr_func_logic.u_epl_mac.u_mac_wrp_mgmt.u_mac_mgmt.%reg_name%_q.%field_name%";
  field {
    AccessType = "RW";
    desc = "On transmit, it is necessary to modify the length of the interframe gap in order to align the
            Start control character on lane 0.  The method is selected: 
            * (0) Always insert additional idle characters to align the Start control character on lane 0.
            * (1) Enable Deficit Idle Count (DIC) - maintain the effective data rate by sometimes inserting and sometimes 
                  deleting idle characters to align the Start control character on lane 0.";
    ValRandomize = true;
  } IFG_ENABLE_DIC[44:44] = 1'h0;
  field {
    AccessType = "RW";
    desc = "Minimum number of idle bytes to transmit.  When DIC is enabled, this is the targeted average minimum
            interframe gap (the actual minimum gap lengths will range from slightly below this value to slightly
            above this value, based on the DIC algorithm).";
    ValRandomize = true;
  } IFG_MIN_BYTES[43:32] = 12'h00c;
  field {
    encode = mac_fault_mode_enum;
    AccessType = "RW";
    desc = "This field controls what the MAC places on the transmit MII:
            * (0) Determined by standard Link Fault Signaling State Diagram.
            * (1) Constant Idle control codes /I/ in all octets.
            * (2) Constant Local Fault Sequence ordered_set.
            * (3) Constant Remote Fault Sequence ordered_set.
            * (4) Constant Link Interruption Sequence ordered_set.
            * (5) Ignore link_fault reported from the Rx MII.  Force Tx link_fault to OK, and send normal traffic when available.
            * (6) Constant Error control codes /V/ in all octets.
            * (7) Constant user defined Sequence or Signal ordered_set (from MAC_TX_SEQUENCE register).";
    ValRandomize = true;
  } FAULT_MODE[31:29] = 3'h0;
  field {
    AccessType = "RW";
    desc = "This bit controls Low Power Idle (LPI) mode:
            * (0) LPI mode is inactive.  LPI will not start automatically.
            * (1->0) If LPI was active it will transition to the WAIT state (see LPI_TIMEOUT).
            * (0->1) If LPI_AUTOMATIC_START is not set, this will activate LPI mode.
            * (1) LPI mode will automatically start if LPI_AUTOMATIC_START is set, and automatically stop if LPI_AUTOMATIC_STOP is set.";
    ValRandomize = true;
  } LPI_REQUEST[28:28] = 1'h0;
  field {
    AccessType = "RW";
    desc = "This bit determines how Low Power Idle mode is entered:
            * (0) Manually setting LPI_REQUEST to 1.
            * (1) Automatically when LPI_REQUEST is 1 and the transmitter has been idle for a period of time specified by LPI_ACTIVITY_TIMEOUT.";
    ValRandomize = true;
  } LPI_AUTOMATIC_START[27:27] = 1'h0;
  field {
    AccessType = "RW";
    desc = "This bit determines how Low Power Idle mode is exited:
            * (0) Manually setting LPI_REQUEST to 0.
            * (1) Automatically when a packet is available to be transmitted.";
    ValRandomize = true;
  } LPI_AUTOMATIC_STOP[26:26] = 1'h0;
  field {
    AccessType = "RW";
    desc = "Minimum delay between exiting Low Power Idle mode and resuming traffic.  Normal IDLE codes are transmitted during this window.
            Units are specified in LPI_TIMESCALE.  Accuracy is 0/+1 unit.";
    ValRandomize = true;
  } LPI_TIMEOUT[25:16] = 10'h0;
  field {
    encode = mac_timescale_enum;
    AccessType = "RW";
    desc = "Units for LPI_TIMEOUT:
            * (0) 100 ns
            * (1) 1 us
            * (2) 10 us
            * (3) 100 us
            * (4) 1 ms
            * (5) 10 ms
            * (6) 100 ms
            * (7) 1 s";
    ValRandomize = true;
  } LPI_TIMESCALE[15:13] = 3'h0;
  field {
    AccessType = "RW";
    desc = "Minimum amount of time required with no activity in the transmit pipeline before
            asserting the MAC_IP.SILENT interrupt.
            Units are specified in LPI_ACTIVITY_TIMESCALE.  Accuracy is 0/+1 unit.";
    ValRandomize = true;
  } LPI_ACTIVITY_TIMEOUT[12:3] = 10'h0;
  field {
    encode = mac_timescale_enum;
    AccessType = "RW";
    desc = "Units for LPI_ACTIVITY_TIMEOUT:
            * (0) 100 ns
            * (1) 1 us
            * (2) 10 us
            * (3) 100 us
            * (4) 1 ms
            * (5) 10 ms
            * (6) 100 ms
            * (7) 1 s";
    ValRandomize = true;
  } LPI_ACTIVITY_TIMESCALE[2:0] = 3'h0;
}; // mac_tx_mii_cfg_r


//------------------------------------------------------------------------------
// MAC_TX_PATH_CFG

reg mac_tx_path_cfg_r {
  Security_PolicyGroup     = <%=$Security_Props{'MBY_PG1'}%>;
  Security_ReadAccess_Str  = <%=$Security_Props{'MBY_PG1_RAC_AGENTS'}%>;
  Security_WriteAccess_Str = <%=$Security_Props{'MBY_PG1_WAC_AGENTS'}%>;
  shared;
  HandCoded = true;
  name = "MAC transmit path configuration";
  desc = "MAC transmit path configuration Register";
  regwidth = 64;
  accesswidth = 64;
  DefaultValRTLSignal = "u_epl_mac_apr_func_logic.u_epl_mac.u_mac_wrp_mgmt.u_mac_mgmt.%reg_name%_q.%field_name%";

  field {
    AccessType = "RW";
    desc = "* (0) Normal operation, port drains all packets automatically when link is down.
            * (1) Force the port to drain all packets regardless of link status. The drain is applied immediately and may cut short an in-flight packet.  Stats are not counted for drained packets, since they don't reach the line, but each partially or fully drained packet causes the MAC_STAT_TX_DRAIN_DROP counter to increment.

            Link status here refers to the result of the Link Fault state machine.  The link is considered up when
            link_fault == OK, otherwise the link is down.";
    ValRandomize = true;
  } DRAIN_MODE[32:32] = 1'h0;
  field {
    AccessType = "RW";
    desc = "Determines which flow control override bits should be used.  There is one bit per
            pause class.
            * (0) Use the hardware signal from the switch interface
            * (1) Use the force_xoff_value bit from this register";
    ValRandomize = true;
  } FORCE_XOFF_ENABLE[31:24] = 8'h0;
  field {
    AccessType = "RW";
    desc = "Flow control bits to override the hardware signals from the switch interface.  Each
            bit represents the corresponding pause class.  A value of 1 in a bit signifies switch
            congestion requiring Pause/PFC.  These bits are used for both
            internal Pause/PFC frame generation, and for direct ONPI xoff signalling.";
    ValRandomize = true;
  } FORCE_XOFF_VALUE[23:16] = 8'h0;
  field {
    AccessType = "RW";
    desc = "Time between flow control packets, measured in units of 512 bit times, +/-512 bit times.";
    ValRandomize = true;
  } PAUSE_TIME[15:0] = 16'h4000;
}; // mac_tx_path_cfg_r


//------------------------------------------------------------------------------
// MAC_TX_SEQUENCE

reg mac_tx_sequence_r {
  Security_PolicyGroup     = <%=$Security_Props{'MBY_PG1'}%>;
  Security_ReadAccess_Str  = <%=$Security_Props{'MBY_PG1_RAC_AGENTS'}%>;
  Security_WriteAccess_Str = <%=$Security_Props{'MBY_PG1_WAC_AGENTS'}%>;
  shared;
  HandCoded = true;
  name = "User programmable Sequence or Signal ordered_set";
  desc = "User programmable Sequence or Signal ordered_set Register";
  regwidth = 64;
  accesswidth = 64;
  DefaultValRTLSignal = "u_epl_mac_apr_func_logic.u_epl_mac.u_mac_wrp_mgmt.u_mac_mgmt.%reg_name%_q.%field_name%";
  field {
    AccessType = "RW";
    desc = "Sequence or Signal ordered_set data values";
    ValRandomize = true;
  } D[31:0] = 32'h0;
}; // mac_tx_sequence_r


//------------------------------------------------------------------------------
// MAC_TX_CONTROL_STATUS

reg mac_tx_control_status_r {
  Security_PolicyGroup     = <%=$Security_Props{'MBY_PG1'}%>;
  Security_ReadAccess_Str  = <%=$Security_Props{'MBY_PG1_RAC_AGENTS'}%>;
  Security_WriteAccess_Str = <%=$Security_Props{'MBY_PG1_WAC_AGENTS'}%>;
  shared;
  HandCoded = true;
  name = "MAC TX Control Status";
  desc = "MAC TX Control Status Register";
  regwidth = 64;
  accesswidth = 64;
  DefaultValRTLSignal = "u_epl_mac_apr_func_logic.u_epl_mac.u_mac_wrp_mgmt.u_mac_mgmt.%reg_name%.%field_name%";
  field {
    AccessType = "RO/V";
    desc = "Current Xoff state being communicated from the switch port.";
    ValRandomize = true;
  } XOFF[24:17] = 8'h0;
  field {
    AccessType = "RO/V";
    desc = "Current value of the pause refresh timer, in units of 128 bit times at the current line rate.";
    ValRandomize = true;
  } PAUSE_REFRESH_TIMER[16:0] = 17'h0;
}; // mac_tx_control_status_r


//------------------------------------------------------------------------------
// MAC_RX_MII_CFG

reg mac_rx_mii_cfg_r {
  Security_PolicyGroup     = <%=$Security_Props{'MBY_PG1'}%>;
  Security_ReadAccess_Str  = <%=$Security_Props{'MBY_PG1_RAC_AGENTS'}%>;
  Security_WriteAccess_Str = <%=$Security_Props{'MBY_PG1_WAC_AGENTS'}%>;
  shared;
  HandCoded = true;
  name = "MAC receive MII configuration";
  desc = "MAC receive MII configuration Register";
  regwidth = 64;
  accesswidth = 64;
  DefaultValRTLSignal = "u_epl_mac_apr_func_logic.u_epl_mac.u_mac_wrp_mgmt.u_mac_mgmt.%reg_name%_q.%field_name%";
  field {
    AccessType = "RW";
    desc = "Disable the Link Fault Signaling state machine
            * (0) Link Fault Signaling state machine enabled.
            * (1) Link Fault Signaling state machine disabled: all link_fault status registers are shown as OK.";
    ValRandomize = true;
  } LINK_FAULT_DISABLE[46:46] = 1'h0;
  field {
    AccessType = "RW";
    desc = "Determines the behavior of the frame's error flag based on the received FCS (the frame isn't modified in either case): 
            * (0) Set the error flag if the received FCS is incorrect.
            * (1) Always set the error flag.";
    ValRandomize = true;
  } FORCE_BAD_FCS[45:45] = 1'h0;
  field {
    AccessType = "RW";
    desc = "* (0) Normal operation
            * (1) Ignore code errors";
    ValRandomize = true;
  } IGNORE_CODE_ERROR[44:44] = 1'h0;
  field {
    AccessType = "RW";
    desc = "Determines the treatment of frames with an incorrect FCS:
            * (0) Frames have their error flag set.
            * (1) Frames do not have their error flag set.";
    ValRandomize = true;
  } IGNORE_FCS_ERROR[43:43] = 1'h0;
  field {
    AccessType = "RW";
    desc = "Ignore interframe gap errors. If not set then checks that at least 1 idle
            column appears before the start of a frame.  Applies for modes other than KR4 and KR2
            which do not have the check in the first place.";
    ValRandomize = true;
  } IGNORE_IFG_ERROR[42:42] = 1'h0;
  field {
    AccessType = "RW";
    desc = "Determines the treatment of oversized frames (length > max_frame_length):
            * (0) Oversized frames are truncated to max_frame_length and have their error flag set.
            * (1) Oversized frames are truncated to max_frame_length and passed to the switch as good.";
    ValRandomize = true;
  } IGNORE_OVERSIZE_ERROR[41:41] = 1'h0;
  field {
    AccessType = "RW";
    desc = "Determines the treatment of undersized frames (length < 64 bytes):
            * (0) Undersized frames are padded to a minimum of 16 bytes and have their error flag set.
            * (1) Undersized frames are passed to the switch as good.";
    ValRandomize = true;
  } IGNORE_UNDERSIZE_ERROR[40:40] = 1'h0;
  field {
    AccessType = "RW";
    desc = "* (0) Normal operation.
            * (1) Ignore preamble errors.";
    ValRandomize = true;
  } IGNORE_PREAMBLE_ERROR[39:39] = 1'h0;
  field {
    AccessType = "RW";
    desc = "Delay for filtering received LPI indications in the active direction.  Transitions from
            non-LPI to LPI use this timer for their debounce window.  Transitions from LPI
            to non-LPI are recognized immediately.
            Units are specified in LPI_RX_TIMESCALE.  Accuracy is 0/+1 unit.";
    ValRandomize = true;
  } LPI_RX_TIMEOUT[38:29] = 10'h0;
  field {
    encode = mac_timescale_enum;
    AccessType = "RW";
    desc = "Units for LPI_RX_TIMEOUT:
            * (0) 100 ns
            * (1) 1 us
            * (2) 10 us
            * (3) 100 us
            * (4) 1 ms
            * (5) 10 ms
            * (6) 100 ms
            * (7) 1 s";
    ValRandomize = true;
  } LPI_RX_TIMESCALE[28:26] = 3'h0;
  field {
    AccessType = "RW";
    desc = "Delay for filtering link status changes in the up direction.  Transitions from
            Local Fault to either Remote Fault or OK use this timer for their debounce window.
            Units are specified in LINK_UP_TIMESCALE.  Accuracy is 0/+1 unit.";
    ValRandomize = true;
  } LINK_UP_TIMEOUT[25:16] = 10'h0;
  field {
    encode = mac_timescale_enum;
    AccessType = "RW";
    desc = "Units for LINK_UP_TIMEOUT:
            * (0) 100 ns
            * (1) 1 us
            * (2) 10 us
            * (3) 100 us
            * (4) 1 ms
            * (5) 10 ms
            * (6) 100 ms
            * (7) 1 s";
    ValRandomize = true;
  } LINK_UP_TIMESCALE[15:13] = 3'h0;
  field {
    AccessType = "RW";
    desc = "Delay for filtering link status changes in the down direction.  Transitions from
            Remote Fault to Local Fault, and from OK to either Remote Fault or Local Fault
            use this timer for their debounce window.
            Units are specified in LINK_DOWN_TIMESCALE.  Accuracy is 0/+1 unit.";
    ValRandomize = true;
  } LINK_DOWN_TIMEOUT[12:3] = 10'h0;
  field {
    encode = mac_timescale_enum;
    AccessType = "RW";
    desc = "Units for LINK_DOWN_TIMEOUT:
            * (0) 100 ns
            * (1) 1 us
            * (2) 10 us
            * (3) 100 us
            * (4) 1 ms
            * (5) 10 ms
            * (6) 100 ms
            * (7) 1 s";
    ValRandomize = true;
  } LINK_DOWN_TIMESCALE[2:0] = 3'h0;
}; // mac_rx_mii_cfg_r


//------------------------------------------------------------------------------
// MAC_RX_PATH_CFG

reg mac_rx_path_cfg_r {
  Security_PolicyGroup     = <%=$Security_Props{'MBY_PG1'}%>;
  Security_ReadAccess_Str  = <%=$Security_Props{'MBY_PG1_RAC_AGENTS'}%>;
  Security_WriteAccess_Str = <%=$Security_Props{'MBY_PG1_WAC_AGENTS'}%>;
  shared;
  HandCoded = true;
  name = "MAC receive path configuration";
  desc = "MAC receive path configuration Register";
  regwidth = 64;
  accesswidth = 64;
  DefaultValRTLSignal = "u_epl_mac_apr_func_logic.u_epl_mac.u_mac_wrp_mgmt.u_mac_mgmt.%reg_name%_q.%field_name%";
  field {
    AccessType = "RW";
    desc = "* (0) Cause received WOL/ROL frames to be dropped by the PB by setting their drop flag.
            * (1) Allow received WOL/ROL frames into the fabric by not setting their drop flag.";
    ValRandomize = true;
  } FORWARD_WOL[22:22] = 1'h0;
  field {
    AccessType = "RW";
    desc = "* (0) Normal operation.
            * (1) Discard all received packets at the MII interface, while still counting stats.  The drain is applied immediately and may cut short an in-flight packet.  All truncated or discarded packets cause the MAC_STAT_RX_DRAIN_DROP counter to increment.";
    ValRandomize = true;
  } DRAIN_MODE[21:21] = 1'h0;
  field {
    AccessType = "RW";
    desc = "Determines which flow control override bits should be used.  There is one bit per
            pause class.
            * (0) Use the value determined by either received Pause/PFC frames or direct ONPI signalling
            * (1) Use the force_xoff_value bit from this register";
    ValRandomize = true;
  } FORCE_XOFF_ENABLE[20:13] = 8'h0;
  field {
    AccessType = "RW";
    desc = "Flow control bits to override the signals being sent to the switch interface.  Each
            bit represents the corresponding pause class.  A value of 1, or XOFF, causes data transmission
            to stop.  A value of 0, or XON, allows data transmission.  These bits are used to override
            both the internally determined signals based on Pause/PFC frame reception, and the direct ONPI
            xoff signals.";
    ValRandomize = true;
  } FORCE_XOFF_VALUE[12:5] = 8'h0;
  field {
    AccessType = "RW";
    desc = "* (0) Cause received Pause frames to be dropped by PB by setting their drop flag.
            * (1) Allow received Pause frames into the switch by not setting their drop flag.";
    ValRandomize = true;
  } FORWARD_PAUSE[4:4] = 1'h0;
  field {
    AccessType = "RW";
    desc = "* (0) Cause received PFC frames to be dropped by PB by setting their drop flag.
            * (1) Allow received PFC frames into the switch by not setting their drop flag.";
    ValRandomize = true;
  } FORWARD_PFC[3:3] = 1'h0;
  field {
    AccessType = "RW";
    desc = "Determines which pause class timer is viewable in MAC_RX_CONTROL_STATUS.SELECTED_PAUSE_TIMER.
            The selected timer is pause_class_timer[SELECT_TIMER].";
    ValRandomize = true;
  } SELECT_TIMER[2:0] = 3'h0;
};


//------------------------------------------------------------------------------
// MAC_RX_PARSER_CFG_1

reg mac_rx_parser_cfg_1_r {
  Security_PolicyGroup     = <%=$Security_Props{'MBY_PG1'}%>;
  Security_ReadAccess_Str  = <%=$Security_Props{'MBY_PG1_RAC_AGENTS'}%>;
  Security_WriteAccess_Str = <%=$Security_Props{'MBY_PG1_WAC_AGENTS'}%>;
  shared;
  HandCoded = true;
  name = "MAC Receive Parser Configuration (1)";
  desc = "MAC Receive Parser Configuration (1) Register";
  regwidth = 64;
  accesswidth = 64;
  DefaultValRTLSignal = "u_epl_mac_apr_func_logic.u_epl_mac.u_mac_wrp_mgmt.u_mac_mgmt.%reg_name%_q.%field_name%";
  field {
    encode = mac_parse_event_enum;
    AccessType = "RW";
    desc = "Determines which type of frame classification event is counted in MAC_RX_PARSER_COUNTER.
            * (0) IPv4
            * (1) IPv6
            * (2) MPLS unicast
            * (3) MPLS multicast
            * (4) VLAN1
            * (5) VLAN2
            * (others) Reserved";
    ValRandomize = true;
  } EVENT_COUNTER_SELECT[38:36] = 3'h0;
  field {
    encode = mac_parse_ethertype_enum;
    AccessType = "RW";
    desc = "Determines how user-defined EtherType 1 will be used to identify packets:
            * (0) Unused
            * (1) Used as VLAN1 (instead of default 0x8100)
            * (2) Used as MPLS Unicast (instead of default 0x8847)
            * (3) Used as IPv4 (instead of default 0x0800)";
    ValRandomize = true;
  } USER_ETHERTYPE1_SEL[35:34] = 2'h0;
  field {
    encode = mac_parse_ethertype_enum;
    AccessType = "RW";
    desc = "Determines how user-defined EtherType 2 will be used to identify packets:
            * (0) Unused
            * (1) Used as VLAN2 (instead of default 0x88A8)
            * (2) Used as MPLS Multicast (instead of default 0x8848)
            * (3) Used as IPv6 (instead of default 0x86DD)";
    ValRandomize = true;
  } USER_ETHERTYPE2_SEL[33:32] = 2'h0;
  field {
    AccessType = "RW";
    desc = "User programmable override that can be used for one of the above EtherType comparisons.";
    ValRandomize = true;
  } USER_ETHERTYPE1[31:16] = 16'h0;
  field {
    AccessType = "RW";
    desc = "User programmable override that can be used for one of the above EtherType comparisons.";
    ValRandomize = true;
  } USER_ETHERTYPE2[15:0] = 16'h0;
};


//------------------------------------------------------------------------------
// MAC_RX_PARSER_CFG_2

reg mac_rx_parser_cfg_2_r {
  Security_PolicyGroup     = <%=$Security_Props{'MBY_PG1'}%>;
  Security_ReadAccess_Str  = <%=$Security_Props{'MBY_PG1_RAC_AGENTS'}%>;
  Security_WriteAccess_Str = <%=$Security_Props{'MBY_PG1_WAC_AGENTS'}%>;
  shared;
  HandCoded = true;
  name = "MAC Receive Parser Configuration (2), classifies packet priority (1-bit)";
  desc = "MAC Receive Parser Configuration (2), classifies packet priority (1-bit) Register";
  regwidth = 64;
  accesswidth = 64;
  DefaultValRTLSignal = "u_epl_mac_apr_func_logic.u_epl_mac.u_mac_wrp_mgmt.u_mac_mgmt.%reg_name%_q.%field_name%";
  field {
    encode = mac_parse_precedence_enum;
    AccessType = "RW";
    desc = "Programmable priority encoding precedence (highest).  The internal traffic class (TC) is
            derived from 4 possible sources: VLAN PCP, MPLS TC, IP DSCP, or packet metadata TC.  The
            4 priority encoding precedence fields determine the order in which these are used.  The
            first one that matches the packet type is used.
            * (0) VLAN
            * (1) MPLS
            * (2) IP
            * (3) RESERVED";
    ValRandomize = true;
  } PRI_PRECEDENCE1[7:6] = 2'h3;
  field {
    encode = mac_parse_precedence_enum;
    AccessType = "RW";
    desc = "Programmable priority encoding precedence (2nd highest).
            * (0) VLAN
            * (1) MPLS
            * (2) IP
            * (3) RESERVED";
    ValRandomize = true;
  } PRI_PRECEDENCE2[5:4] = 2'h2;
  field {
    encode = mac_parse_precedence_enum;
    AccessType = "RW";
    desc = "Programmable priority encoding precedence (3rd highest).
            * (0) VLAN
            * (1) MPLS
            * (2) IP
            * (3) RESERVED";
    ValRandomize = true;
  } PRI_PRECEDENCE3[3:2] = 2'h1;
  field {
    encode = mac_parse_precedence_enum;
    AccessType = "RW";
    desc = "Programmable priority encoding precedence (4th highest).
            * (0) VLAN
            * (1) MPLS
            * (2) IP
            * (3) RESERVED";
    ValRandomize = true;
  } PRI_PRECEDENCE4[1:0] = 2'h0;
};


//------------------------------------------------------------------------------
// MAC_RX_PARSER_VLAN_TC

reg mac_rx_parser_vlan_tc_r {
  Security_PolicyGroup     = <%=$Security_Props{'MBY_PG1'}%>;
  Security_ReadAccess_Str  = <%=$Security_Props{'MBY_PG1_RAC_AGENTS'}%>;
  Security_WriteAccess_Str = <%=$Security_Props{'MBY_PG1_WAC_AGENTS'}%>;
  shared;
  HandCoded = true;
  name = "MAC Receive Parser VLAN Priority to TC mapping table";
  desc = "MAC Receive Parser VLAN Priority to TC mapping table.  Each VLAN Priority corresponds to a Traffic Class value";
  regwidth = 64;
  accesswidth = 64;
  DefaultValRTLSignal = "u_epl_mac_apr_func_logic.u_epl_mac.u_mac_wrp_mgmt.u_mac_mgmt.%reg_name%_q.%field_name%";
  field {
    AccessType = "RW";
    desc = "Traffic Class for VLAN Priority 7";
    ValRandomize = true;
  } VLAN_PRI7_TC[30:28] = 3'h0;
  field {
    AccessType = "RW";
    desc = "Traffic Class for VLAN Priority 6";
    ValRandomize = true;
  } VLAN_PRI6_TC[26:24] = 3'h0;
  field {
    AccessType = "RW";
    desc = "Traffic Class for VLAN Priority 5";
    ValRandomize = true;
  } VLAN_PRI5_TC[22:20] = 3'h0;
  field {
    AccessType = "RW";
    desc = "Traffic Class for VLAN Priority 4";
    ValRandomize = true;
  } VLAN_PRI4_TC[18:16] = 3'h0;
  field {
    AccessType = "RW";
    desc = "Traffic Class for VLAN Priority 3";
    ValRandomize = true;
  } VLAN_PRI3_TC[14:12] = 3'h0;
  field {
    AccessType = "RW";
    desc = "Traffic Class for VLAN Priority 2";
    ValRandomize = true;
  } VLAN_PRI2_TC[10:8] = 3'h0;
  field {
    AccessType = "RW";
    desc = "Traffic Class for VLAN Priority 1";
    ValRandomize = true;
  } VLAN_PRI1_TC[6:4] = 3'h0;
  field {
    AccessType = "RW";
    desc = "Traffic Class for VLAN Priority 0";
    ValRandomize = true;
  } VLAN_PRI0_TC[2:0] = 3'h0;
};


//------------------------------------------------------------------------------
// MAC_RX_PARSER_MPLS_TC

reg mac_rx_parser_mpls_tc_r {
  Security_PolicyGroup     = <%=$Security_Props{'MBY_PG1'}%>;
  Security_ReadAccess_Str  = <%=$Security_Props{'MBY_PG1_RAC_AGENTS'}%>;
  Security_WriteAccess_Str = <%=$Security_Props{'MBY_PG1_WAC_AGENTS'}%>;
  shared;
  HandCoded = true;
  name = "MAC Receive Parser MPLS Priority to TC mapping table";
  desc = "MAC Receive Parser MPLS Priority to TC mapping table.  Each MPLS Priority corresponds to a Traffic Class value";
  regwidth = 64;
  accesswidth = 64;
  DefaultValRTLSignal = "u_epl_mac_apr_func_logic.u_epl_mac.u_mac_wrp_mgmt.u_mac_mgmt.%reg_name%_q.%field_name%";
  field {
    AccessType = "RW";
    desc = "Traffic Class for VLAN Priority 7";
    ValRandomize = true;
  } MPLS_PRI7_TC[30:28] = 3'h0;
  field {
    AccessType = "RW";
    desc = "Traffic Class for VLAN Priority 6";
    ValRandomize = true;
  } MPLS_PRI6_TC[26:24] = 3'h0;
  field {
    AccessType = "RW";
    desc = "Traffic Class for VLAN Priority 5";
    ValRandomize = true;
  } MPLS_PRI5_TC[22:20] = 3'h0;
  field {
    AccessType = "RW";
    desc = "Traffic Class for VLAN Priority 4";
    ValRandomize = true;
  } MPLS_PRI4_TC[18:16] = 3'h0;
  field {
    AccessType = "RW";
    desc = "Traffic Class for VLAN Priority 3";
    ValRandomize = true;
  } MPLS_PRI3_TC[14:12] = 3'h0;
  field {
    AccessType = "RW";
    desc = "Traffic Class for VLAN Priority 2";
    ValRandomize = true;
  } MPLS_PRI2_TC[10:8] = 3'h0;
  field {
    AccessType = "RW";
    desc = "Traffic Class for VLAN Priority 1";
    ValRandomize = true;
  } MPLS_PRI1_TC[6:4] = 3'h0;
  field {
    AccessType = "RW";
    desc = "Traffic Class for VLAN Priority 0";
    ValRandomize = true;
  } MPLS_PRI0_TC[2:0] = 3'h0;
};


//------------------------------------------------------------------------------
// MAC_RX_PARSER_DSCP_TC

reg mac_rx_parser_dscp_tc_r {
  Security_PolicyGroup     = <%=$Security_Props{'MBY_PG1'}%>;
  Security_ReadAccess_Str  = <%=$Security_Props{'MBY_PG1_RAC_AGENTS'}%>;
  Security_WriteAccess_Str = <%=$Security_Props{'MBY_PG1_WAC_AGENTS'}%>;
  shared;
  HandCoded = true;
  name = "MAC Receive Parser DSCP to TC mapping table";
  desc = "MAC Receive Parser DSCP to TC mapping table.  Each DSCP value index to a register that contains a Traffic Class value";
  regwidth = 64;
  accesswidth = 64;
  DefaultValRTLSignal = "u_epl_mac_apr_func_logic.u_epl_mac.u_mac_wrp_mgmt.u_mac_mgmt.%reg_name%_q.%field_name%";
  field {
    AccessType = "RW";
    desc = "Traffic Class";
    ValRandomize = true;
  } TC[2:0] = 3'h0;
};

// MAC_RX_PARSER_DEFAULT_TC

reg mac_rx_parser_default_tc_r {
  Security_PolicyGroup     = <%=$Security_Props{'MBY_PG1'}%>;
  Security_ReadAccess_Str  = <%=$Security_Props{'MBY_PG1_RAC_AGENTS'}%>;
  Security_WriteAccess_Str = <%=$Security_Props{'MBY_PG1_WAC_AGENTS'}%>;
  shared;
  HandCoded = true;
  name = "MAC Receive Parser Default Traffic Class";
  desc = "MAC Receive Parser Default Traffic Class";
  regwidth = 64;
  accesswidth = 64;
  DefaultValRTLSignal = "u_epl_mac_apr_func_logic.u_epl_mac.u_mac_wrp_mgmt.u_mac_mgmt.%reg_name%_q.%field_name%";
  field {
    AccessType = "RW";
    desc = "Traffic Class";
    ValRandomize = true;
  } TC[2:0] = 3'h0;
};

//------------------------------------------------------------------------------
// MAC_RX_SEQUENCE

reg mac_rx_sequence_r {
  Security_PolicyGroup     = <%=$Security_Props{'MBY_PG1'}%>;
  Security_ReadAccess_Str  = <%=$Security_Props{'MBY_PG1_RAC_AGENTS'}%>;
  Security_WriteAccess_Str = <%=$Security_Props{'MBY_PG1_WAC_AGENTS'}%>;
  shared;
  HandCoded = true;
  name = "Last received Sequence or Signal ordered_set";
  desc = "Last received Sequence or Signal ordered_set Register";
  regwidth = 64;
  accesswidth = 64;
  DefaultValRTLSignal = "u_epl_mac_apr_func_logic.u_epl_mac.u_mac_wrp_mgmt.u_mac_mgmt.%reg_name%.%field_name%";
  field {
    AccessType = "RO/V";
    desc = "Last Sequence or Signal ordered_set data values.";
    ValRandomize = true;
  } D[31:0] = 32'h0;
};


//------------------------------------------------------------------------------
// MAC_RX_CONTROL_STATUS

reg mac_rx_control_status_r {
  Security_PolicyGroup     = <%=$Security_Props{'MBY_PG1'}%>;
  Security_ReadAccess_Str  = <%=$Security_Props{'MBY_PG1_RAC_AGENTS'}%>;
  Security_WriteAccess_Str = <%=$Security_Props{'MBY_PG1_WAC_AGENTS'}%>;
  shared;
  HandCoded = true;
  name = "MAC RX Control Status";
  desc = "MAC RX Control Status Register";
  regwidth = 64;
  accesswidth = 64;
  DefaultValRTLSignal = "u_epl_mac_apr_func_logic.u_epl_mac.u_mac_wrp_mgmt.u_mac_mgmt.%reg_name%.%field_name%";
  field {
    AccessType = "RO/V";
    desc = "Current Xoff state being communicated to the switch port.";
    ValRandomize = true;
  } XOFF[48:41] = 8'h0;
  field {
    AccessType = "RO/V";
    desc = "Pause timer done status.";
    ValRandomize = true;
  } PAUSE_TIMER_DONE[40:40] = 1'h0;
  field {
    AccessType = "RO/V";
    desc = "PFC per pause class timer done status.";
    ValRandomize = true;
  } PFC_TIMER_DONE[39:32] = 8'h0;
  field {
    AccessType = "RO/V";
    desc = "Last priority enable vector received in a valid PFC frame.";
    ValRandomize = true;
  } PRIORITY_ENABLE_VECTOR[31:16] = 16'h0;
  field {
    AccessType = "RO/V";
    desc = "Pause timer selected by MAC_RX_PATH_CFG.SELECT_TIMER.";
    ValRandomize = true;
  } SELECTED_PAUSE_TIMER[15:0] = 16'h0;
};


//------------------------------------------------------------------------------
// MAC_RX_LINK_COUNTER

reg mac_rx_link_counter_r {
  Security_PolicyGroup     = <%=$Security_Props{'MBY_PG1'}%>;
  Security_ReadAccess_Str  = <%=$Security_Props{'MBY_PG1_RAC_AGENTS'}%>;
  Security_WriteAccess_Str = <%=$Security_Props{'MBY_PG1_WAC_AGENTS'}%>;
  shared;
  HandCoded = true;
  name = "MAC Rx Link Status Counters";
  desc = "MAC Rx Link Status Counters Register";
  regwidth = 64;
  accesswidth = 64;
  DefaultValRTLSignal = "u_epl_mac_apr_func_logic.u_epl_mac.u_mac_wrp_mgmt.u_mac_mgmt.%reg_name%_q.%field_name%";
  field {
    AccessType = "RW/V";
    desc = "Number of transitions to No Fault";
    ValRandomize = true;
  } NO_FAULT[31:20] = 12'h0;
  field {
    AccessType = "RW/V";
    desc = "Number of transitions to Local Fault";
    ValRandomize = true;
  } LOCAL_FAULT[19:10] = 10'h0;
  field {
    AccessType = "RW/V";
    desc = "Number of transitions to Remote Fault";
    ValRandomize = true;
  } REMOTE_FAULT[9:0] = 10'h0;
};


//------------------------------------------------------------------------------
// MAC_RX_PARSER_COUNTER

reg mac_rx_parser_counter_r {
  Security_PolicyGroup     = <%=$Security_Props{'MBY_PG1'}%>;
  Security_ReadAccess_Str  = <%=$Security_Props{'MBY_PG1_RAC_AGENTS'}%>;
  Security_WriteAccess_Str = <%=$Security_Props{'MBY_PG1_WAC_AGENTS'}%>;
  shared;
  HandCoded = true;
  name = "MAC Rx Parser Event Counter";
  desc = "MAC Rx Parser Event Counter Register";
  regwidth = 64;
  accesswidth = 64;
  DefaultValRTLSignal = "u_epl_mac_apr_func_logic.u_epl_mac.u_mac_wrp_mgmt.u_mac_mgmt.%reg_name%_q.%field_name%";
  field {
    AccessType = "RW/V";
    desc = "Count of frame classification events determined by MAC_RX_PARSER_CFG_1.EVENT_COUNTER_SELECT.";
    ValRandomize = true;
  } COUNT[31:0] = 32'h0;
}; // mac_rx_parser_counter_r


//------------------------------------------------------------------------------
// MAC_PIA_CFG

reg mac_pia_cfg_r {
  Security_PolicyGroup     = <%=$Security_Props{'MBY_PG1'}%>;
  Security_ReadAccess_Str  = <%=$Security_Props{'MBY_PG1_RAC_AGENTS'}%>;
  Security_WriteAccess_Str = <%=$Security_Props{'MBY_PG1_WAC_AGENTS'}%>;
  shared;
  HandCoded = true;
  name = "MAC Packet Interface Adapter (PIA/ONPI) Configuration";
  desc = "MAC Packet Interface Adapter (PIA/ONPI) Configuration Register";
  regwidth = 64;
  accesswidth = 64;
  DefaultValRTLSignal = "u_epl_mac_apr_func_logic.u_epl_mac.u_mac_wrp_mgmt.u_mac_mgmt.%reg_name%_q.%field_name%";
  field {
    AccessType = "RW";
    desc = "* (0) ONPI xoff signals are disabled.
            * (1) ONPI xoff signals are connected to the switch interface.";
    ValRandomize = true;
  } XOFF_ENABLE[10:10] = 1'h0;
  field {
    AccessType = "RW";
    desc = "* (0) ONPI operates in slave mode, receiving configuration from the PHY.
            * (1) ONPI operates in master mode, using the options specified in this register.";
    ValRandomize = true;
  } ONPI_MASTER_MODE[9:9] = 1'h0;
  field {
    encode = mac_onpi_speed_enum;
    AccessType = "RW";
    desc = "ONPI master mode speed option:
            * (0) Reserved
            * (1) Reserved
            * (2) 1 Gbps
            * (3) 2.5 Gbps
            * (4) 5 Gbps
            * (5) 10 Gbps
            * (6) Reserved
            * (7) 25 Gbps
            * (8) Reserved
            * (9) 50 Gbps
            * (10) 100 Gbps
            * (11) 200G";
    ValRandomize = true;
  } ONPI_SPEED[8:1] = 1'h0;
  field {
    AccessType = "RW";
    desc = "* (0) Disable PIA/ONPI interface.
            * (1) Enable PIA/ONPI interface.";
    ValRandomize = true;
  } ONPI_ENABLE[0:0] = 1'h0;
};


//------------------------------------------------------------------------------
// MAC_PIA_STATUS

reg mac_pia_status_r {
  Security_PolicyGroup     = <%=$Security_Props{'MBY_PG1'}%>;
  Security_ReadAccess_Str  = <%=$Security_Props{'MBY_PG1_RAC_AGENTS'}%>;
  Security_WriteAccess_Str = <%=$Security_Props{'MBY_PG1_WAC_AGENTS'}%>;
  shared;
  HandCoded = true;
  name = "MAC Packet Interface Adapter (PIA/ONPI) Status";
  desc = "MAC Packet Interface Adapter (PIA/ONPI) Status Register";
  regwidth = 64;
  accesswidth = 64;
  DefaultValRTLSignal = "u_epl_mac_apr_func_logic.u_epl_mac.u_mac_wrp_mgmt.u_mac_mgmt.%reg_name%.%field_name%";
  field {
    encode = mac_onpi_speed_enum;
    AccessType = "RO/V";
    desc = "ONPI speed:
            * (0) Reserved
            * (1) Reserved
            * (2) 1 Gbps
            * (3) 2.5 Gbps
            * (4) 5 Gbps
            * (5) 10 Gbps
            * (6) Reserved
            * (7) 25 Gbps
            * (8) Reserved
            * (9) 50 Gbps
            * (10) 100 Gbps
            * (11) 200G";
    ValRandomize = true;
  } ONPI_SPEED[31:24] = 1'h0;
  field {
    AccessType = "RO/V";
    desc = "Current Tx FIFO depth.";
    ValRandomize = true;
  } TX_FIFO_DEPTH[23:19] = 1'h0;
  field {
    AccessType = "RO/V";
    desc = "Tx FIFO full flag.";
    ValRandomize = true;
  } TX_FIFO_FULL[18:18] = 1'h0;
  field {
    AccessType = "RO/V";
    desc = "Tx FIFO almost full flag.";
    ValRandomize = true;
  } TX_FIFO_AFULL[17:17] = 1'h0;
  field {
    AccessType = "RO/V";
    desc = "Tx FIFO almost empty flag.";
    ValRandomize = true;
  } TX_FIFO_AEMPTY[16:16] = 1'h0;
  field {
    AccessType = "RO/V";
    desc = "Tx FIFO empty flag.";
    ValRandomize = true;
  } TX_FIFO_EMPTY[15:15] = 1'h0;
  field {
    AccessType = "RO/V";
    desc = "Tx FIFO parity error.";
    ValRandomize = true;
  } TX_FIFO_PARITY_ERR[14:14] = 1'h0;
  field {
    AccessType = "RO/V";
    desc = "Tx FIFO overflow.";
    ValRandomize = true;
  } TX_FIFO_OVERFLOW[13:13] = 1'h0;
  field {
    AccessType = "RO/V";
    desc = "Tx FIFO underflow.";
    ValRandomize = true;
  } TX_FIFO_UNDERFLOW[12:12] = 1'h0;
  field {
    AccessType = "RO/V";
    desc = "Current Rx FIFO depth.";
    ValRandomize = true;
  } RX_FIFO_DEPTH[11:7] = 1'h0;
  field {
    AccessType = "RO/V";
    desc = "Rx FIFO full flag.";
    ValRandomize = true;
  } RX_FIFO_FULL[6:6] = 1'h0;
  field {
    AccessType = "RO/V";
    desc = "Rx FIFO almost full flag.";
    ValRandomize = true;
  } RX_FIFO_AFULL[5:5] = 1'h0;
  field {
    AccessType = "RO/V";
    desc = "Rx FIFO almost empty flag.";
    ValRandomize = true;
  } RX_FIFO_AEMPTY[4:4] = 1'h0;
  field {
    AccessType = "RO/V";
    desc = "Rx FIFO empty flag.";
    ValRandomize = true;
  } RX_FIFO_EMPTY[3:3] = 1'h0;
  field {
    AccessType = "RO/V";
    desc = "Rx FIFO parity error.";
    ValRandomize = true;
  } RX_FIFO_PARITY_ERR[2:2] = 1'h0;
  field {
    AccessType = "RO/V";
    desc = "Rx FIFO overflow.";
    ValRandomize = true;
  } RX_FIFO_OVERFLOW[1:1] = 1'h0;
  field {
    AccessType = "RO/V";
    desc = "Rx FIFO underflow.";
    ValRandomize = true;
  } RX_FIFO_UNDERFLOW[0:0] = 1'h0;
}; // mac_rx_parser_counter_r

//------------------------------------------------------------------------------
// MAC_XOFF_TIME_THRESHOLD

reg mac_xoff_time_threshold_r {
  Security_PolicyGroup     = <%=$Security_Props{'MBY_PG1'}%>;
  Security_ReadAccess_Str  = <%=$Security_Props{'MBY_PG1_RAC_AGENTS'}%>;
  Security_WriteAccess_Str = <%=$Security_Props{'MBY_PG1_WAC_AGENTS'}%>;
  shared;
  HandCoded = true;
  name = "MAC XOFF Assertion Time Threshold Register";
  desc = "MAC XOFF Assertion Time Threshold Register";
  regwidth = 64;
  accesswidth = 64;
  DefaultValRTLSignal = "u_epl_mac_apr_func_logic.u_epl_mac.u_mac_wrp_mgmt.u_mac_mgmt.%reg_name%_q.%field_name%";
  field {
    AccessType = "RW/V";
    desc = "Enable XOFF Assertion Timer Threshold";
    ValRandomize = true;
  } TIMER_EN[16:16] = 1'h0;
  field {
    AccessType = "RW";
    desc = "XOFF Time threshold for interrupt generation.";
    ValRandomize = true;
  } XOFF_TIMEOUT[13:4] = 10'h0;
  field {
    encode = mac_timescale_enum;
    AccessType = "RW";
    desc = "Units for XOFF_TIMEOUT:
            * (0) 100 ns
            * (1) 1 us
            * (2) 10 us
            * (3) 100 us
            * (4) 1 ms
            * (5) 10 ms
            * (6) 100 ms
            * (7) 1 s";
    ValRandomize = true;
  } XOFF_TIMESCALE[2:0] = 3'h0;
}; // mac_xoff_time_threshold_r


//------------------------------------------------------------------------------
// MAC_STAT_TX_OCTET

reg mac_stat_tx_octet_r {
  Security_PolicyGroup     = <%=$Security_Props{'MBY_PG1'}%>;
  Security_ReadAccess_Str  = <%=$Security_Props{'MBY_PG1_RAC_AGENTS'}%>;
  Security_WriteAccess_Str = <%=$Security_Props{'MBY_PG1_WAC_AGENTS'}%>;
  shared;
  HandCoded = true;
  name = "MAC Statistic Tx Octets";
  desc = "Stat: octets transmitted in all frames";
  regwidth = 64;
  accesswidth = 64;
  field {
    AccessType = "RO/V";
    desc = "Octets transmitted in all frames.";
    ValRandomize = true;
  } COUNT[63:0] = 64'h0;
};


//------------------------------------------------------------------------------
// MAC_STAT_TX_BAD_OCTET

reg mac_stat_tx_bad_octet_r {
  Security_PolicyGroup     = <%=$Security_Props{'MBY_PG1'}%>;
  Security_ReadAccess_Str  = <%=$Security_Props{'MBY_PG1_RAC_AGENTS'}%>;
  Security_WriteAccess_Str = <%=$Security_Props{'MBY_PG1_WAC_AGENTS'}%>;
  shared;
  HandCoded = true;
  name = "MAC Statistic Tx Bad Octets";
  desc = "Count of bad octets from MAC_STAT_TX_BAD_FRAME";
  regwidth = 64;
  accesswidth = 64;
  field {
    AccessType = "RO/V";
    desc = "Octets transmitted in all bad frames.";
    ValRandomize = true;
  } COUNT[63:0] = 64'h0;
};


//------------------------------------------------------------------------------
// MAC_STAT_TX_FRAME

reg mac_stat_tx_frame_r {
  Security_PolicyGroup     = <%=$Security_Props{'MBY_PG1'}%>;
  Security_ReadAccess_Str  = <%=$Security_Props{'MBY_PG1_RAC_AGENTS'}%>;
  Security_WriteAccess_Str = <%=$Security_Props{'MBY_PG1_WAC_AGENTS'}%>;
  shared;
  HandCoded = true;
  name = "MAC Statistic Tx Frames";
  desc = "Stat: frames transmitted";
  regwidth = 64;
  accesswidth = 64;
  field {
    AccessType = "RO/V";
    desc = "Frames transmitted.";
    ValRandomize = true;
  } COUNT[63:0] = 64'h0;
};


//------------------------------------------------------------------------------
// MAC_STAT_TX_BAD_FRAME

reg mac_stat_tx_bad_frame_r {
  Security_PolicyGroup     = <%=$Security_Props{'MBY_PG1'}%>;
  Security_ReadAccess_Str  = <%=$Security_Props{'MBY_PG1_RAC_AGENTS'}%>;
  Security_WriteAccess_Str = <%=$Security_Props{'MBY_PG1_WAC_AGENTS'}%>;
  shared;
  HandCoded = true;
  name = "MAC Statistic Tx Bad Frames";
  desc = "Counts well-formed packets of any length with CRC polluted.";
  regwidth = 64;
  accesswidth = 64;
  field {
    AccessType = "RO/V";
    desc = "Bad frames transmitted.";
    ValRandomize = true;
  } COUNT[63:0] = 64'h0;
};


//------------------------------------------------------------------------------
// MAC_STAT_TX_CONTROL

reg mac_stat_tx_control_r {
  Security_PolicyGroup     = <%=$Security_Props{'MBY_PG1'}%>;
  Security_ReadAccess_Str  = <%=$Security_Props{'MBY_PG1_RAC_AGENTS'}%>;
  Security_WriteAccess_Str = <%=$Security_Props{'MBY_PG1_WAC_AGENTS'}%>;
  shared;
  HandCoded = true;
  name = "MAC Statistic Tx Control Frames";
  desc = "Stat: Pause and PFC MAC Control frames transmitted";
  regwidth = 64;
  accesswidth = 64;
  field {
    AccessType = "RO/V";
    desc = "Stats: Pause and PFC MAC Control frames transmitted.";
    ValRandomize = true;
  } COUNT[63:0] = 64'h0;
};


//------------------------------------------------------------------------------
// MAC_STAT_TX_FCS_ERROR

reg mac_stat_tx_fcs_error_r {
  Security_PolicyGroup     = <%=$Security_Props{'MBY_PG1'}%>;
  Security_ReadAccess_Str  = <%=$Security_Props{'MBY_PG1_RAC_AGENTS'}%>;
  Security_WriteAccess_Str = <%=$Security_Props{'MBY_PG1_WAC_AGENTS'}%>;
  shared;
  HandCoded = true;
  name = "MAC Statistic Tx FCS Error";
  desc = "Stat: Counts any well-formed packet of valid length which have their CRC polluted";
  regwidth = 64;
  accesswidth = 64;
  field {
    AccessType = "RO/V";
    desc = "Frames transmitted to the line with a CRC error.";
    ValRandomize = true;
  } COUNT[63:0] = 64'h0;
};

//------------------------------------------------------------------------------
// MAC_STAT_TX_UC

reg mac_stat_tx_uc_r {
  Security_PolicyGroup     = <%=$Security_Props{'MBY_PG1'}%>;
  Security_ReadAccess_Str  = <%=$Security_Props{'MBY_PG1_RAC_AGENTS'}%>;
  Security_WriteAccess_Str = <%=$Security_Props{'MBY_PG1_WAC_AGENTS'}%>;
  shared;
  HandCoded = true;
  name = "MAC Statistic Tx Unicast Frame";
  desc = "Stat: frames transmitted as unicast frame";
  regwidth = 64;
  accesswidth = 64;
  field {
    AccessType = "RO/V";
    desc = "Frames transmitted as unicast frame";
    ValRandomize = true;
  } COUNT[63:0] = 64'h0;
};


//------------------------------------------------------------------------------
// MAC_STAT_TX_MC

reg mac_stat_tx_mc_r {
  Security_PolicyGroup     = <%=$Security_Props{'MBY_PG1'}%>;
  Security_ReadAccess_Str  = <%=$Security_Props{'MBY_PG1_RAC_AGENTS'}%>;
  Security_WriteAccess_Str = <%=$Security_Props{'MBY_PG1_WAC_AGENTS'}%>;
  shared;
  HandCoded = true;
  name = "MAC Statistic Tx Multicast Frame";
  desc = "Stat: frames transmitted as multicast frame";
  regwidth = 64;
  accesswidth = 64;
  field {
    AccessType = "RO/V";
    desc = "Frames transmitted as multicast frame";
    ValRandomize = true;
  } COUNT[63:0] = 64'h0;
};

//------------------------------------------------------------------------------
// MAC_STAT_TX_BC

reg mac_stat_tx_bc_r {
  Security_PolicyGroup     = <%=$Security_Props{'MBY_PG1'}%>;
  Security_ReadAccess_Str  = <%=$Security_Props{'MBY_PG1_RAC_AGENTS'}%>;
  Security_WriteAccess_Str = <%=$Security_Props{'MBY_PG1_WAC_AGENTS'}%>;
  shared;
  HandCoded = true;
  name = "MAC Statistic Tx Broadcast Frame";
  desc = "Stat: frames transmitted as broadcast frame";
  regwidth = 64;
  accesswidth = 64;
  field {
    AccessType = "RO/V";
    desc = "Frames transmitted as broadcast frame";
    ValRandomize = true;
  } COUNT[63:0] = 64'h0;
};



//------------------------------------------------------------------------------
// MAC_STAT_TX_64

reg mac_stat_tx_64_r {
  Security_PolicyGroup     = <%=$Security_Props{'MBY_PG1'}%>;
  Security_ReadAccess_Str  = <%=$Security_Props{'MBY_PG1_RAC_AGENTS'}%>;
  Security_WriteAccess_Str = <%=$Security_Props{'MBY_PG1_WAC_AGENTS'}%>;
  shared;
  HandCoded = true;
  name = "MAC Statistic Tx Length 64";
  desc = "Stat: frames transmitted with length == 64";
  regwidth = 64;
  accesswidth = 64;
  field {
    AccessType = "RO/V";
    desc = "Frames transmitted with length == 64.";
    ValRandomize = true;
  } COUNT[63:0] = 64'h0;
};


//------------------------------------------------------------------------------
// MAC_STAT_TX_65

reg mac_stat_tx_65_r {
  Security_PolicyGroup     = <%=$Security_Props{'MBY_PG1'}%>;
  Security_ReadAccess_Str  = <%=$Security_Props{'MBY_PG1_RAC_AGENTS'}%>;
  Security_WriteAccess_Str = <%=$Security_Props{'MBY_PG1_WAC_AGENTS'}%>;
  shared;
  HandCoded = true;
  name = "MAC Statistic Tx Length 65";
  desc = "Stat: frames transmitted with length from 65 through 127";
  regwidth = 64;
  accesswidth = 64;
  field {
    AccessType = "RO/V";
    desc = "Frames transmitted with length from 65 through 127.";
    ValRandomize = true;
  } COUNT[63:0] = 64'h0;
};


//------------------------------------------------------------------------------
// MAC_STAT_TX_128

reg mac_stat_tx_128_r {
  Security_PolicyGroup     = <%=$Security_Props{'MBY_PG1'}%>;
  Security_ReadAccess_Str  = <%=$Security_Props{'MBY_PG1_RAC_AGENTS'}%>;
  Security_WriteAccess_Str = <%=$Security_Props{'MBY_PG1_WAC_AGENTS'}%>;
  shared;
  HandCoded = true;
  name = "MAC Statistic Tx Length 128";
  desc = "Stat: frames transmitted with length from 128 through 255";
  regwidth = 64;
  accesswidth = 64;
  field {
    AccessType = "RO/V";
    desc = "Frames transmitted with length from 128 through 255.";
    ValRandomize = true;
  } COUNT[63:0] = 64'h0;
};


//------------------------------------------------------------------------------
// MAC_STAT_TX_256

reg mac_stat_tx_256_r {
  Security_PolicyGroup     = <%=$Security_Props{'MBY_PG1'}%>;
  Security_ReadAccess_Str  = <%=$Security_Props{'MBY_PG1_RAC_AGENTS'}%>;
  Security_WriteAccess_Str = <%=$Security_Props{'MBY_PG1_WAC_AGENTS'}%>;
  shared;
  HandCoded = true;
  name = "MAC Statistic Tx Length 256";
  desc = "Stat: frames transmitted with length from 256 through 511";
  regwidth = 64;
  accesswidth = 64;
  field {
    AccessType = "RO/V";
    desc = "Frames transmitted with length from 256 through 511.";
    ValRandomize = true;
  } COUNT[63:0] = 64'h0;
};


//------------------------------------------------------------------------------
// MAC_STAT_TX_512

reg mac_stat_tx_512_r {
  Security_PolicyGroup     = <%=$Security_Props{'MBY_PG1'}%>;
  Security_ReadAccess_Str  = <%=$Security_Props{'MBY_PG1_RAC_AGENTS'}%>;
  Security_WriteAccess_Str = <%=$Security_Props{'MBY_PG1_WAC_AGENTS'}%>;
  shared;
  HandCoded = true;
  name = "MAC Statistic Tx Length 512";
  desc = "Stat: frames transmitted with length from 512 through 1023";
  regwidth = 64;
  accesswidth = 64;
  field {
    AccessType = "RO/V";
    desc = "Frames transmitted with length from 512 through 1023.";
    ValRandomize = true;
  } COUNT[63:0] = 64'h0;
};


//------------------------------------------------------------------------------
// MAC_STAT_TX_1024

reg mac_stat_tx_1024_r {
  Security_PolicyGroup     = <%=$Security_Props{'MBY_PG1'}%>;
  Security_ReadAccess_Str  = <%=$Security_Props{'MBY_PG1_RAC_AGENTS'}%>;
  Security_WriteAccess_Str = <%=$Security_Props{'MBY_PG1_WAC_AGENTS'}%>;
  shared;
  HandCoded = true;
  name = "MAC Statistic Tx Length 1024";
  desc = "Stat: frames transmitted with length from 1024 through 1518";
  regwidth = 64;
  accesswidth = 64;
  field {
    AccessType = "RO/V";
    desc = "Frames transmitted with length from 1024 through 1519.";
    ValRandomize = true;
  } COUNT[63:0] = 64'h0;
};


//------------------------------------------------------------------------------
// MAC_STAT_TX_1519

reg mac_stat_tx_1519_r {
  Security_PolicyGroup     = <%=$Security_Props{'MBY_PG1'}%>;
  Security_ReadAccess_Str  = <%=$Security_Props{'MBY_PG1_RAC_AGENTS'}%>;
  Security_WriteAccess_Str = <%=$Security_Props{'MBY_PG1_WAC_AGENTS'}%>;
  shared;
  HandCoded = true;
  name = "MAC Statistic Tx Length 1519";
  desc = "Stat: frames transmitted with length from 1519 through max_length";
  regwidth = 64;
  accesswidth = 64;
  field {
    AccessType = "RO/V";
    desc = "Frames transmitted with length from 1519 through max_length.";
    ValRandomize = true;
  } COUNT[63:0] = 64'h0;
};


//------------------------------------------------------------------------------
// MAC_STAT_TX_OVERSIZE

reg mac_stat_tx_oversize_r {
  Security_PolicyGroup     = <%=$Security_Props{'MBY_PG1'}%>;
  Security_ReadAccess_Str  = <%=$Security_Props{'MBY_PG1_RAC_AGENTS'}%>;
  Security_WriteAccess_Str = <%=$Security_Props{'MBY_PG1_WAC_AGENTS'}%>;
  shared;
  HandCoded = true;
  name = "MAC Statistic Tx Oversize";
  desc = "Stat: frames transmitted with length > max_length and a good CRC";
  regwidth = 64;
  accesswidth = 64;
  field {
    AccessType = "RO/V";
    desc = "Frames transmitted with length > max_length and a good CRC.";
    ValRandomize = true;
  } COUNT[63:0] = 64'h0;
};


//------------------------------------------------------------------------------
// MAC_STAT_TX_JABBER

reg mac_stat_tx_jabber_r {
  Security_PolicyGroup     = <%=$Security_Props{'MBY_PG1'}%>;
  Security_ReadAccess_Str  = <%=$Security_Props{'MBY_PG1_RAC_AGENTS'}%>;
  Security_WriteAccess_Str = <%=$Security_Props{'MBY_PG1_WAC_AGENTS'}%>;
  shared;
  HandCoded = true;
  name = "MAC Statistic Tx Jabber";
  desc = "Stat: frames transmitted with length > max_length and a bad CRC";
  regwidth = 64;
  accesswidth = 64;
  field {
    AccessType = "RO/V";
    desc = "Frames transmitted with length > max_length and a bad CRC.";
    ValRandomize = true;
  } COUNT[63:0] = 64'h0;
};

//------------------------------------------------------------------------------
// MAC_STAT_TX_UNDERRUN

reg mac_stat_tx_underrun_r {
  Security_PolicyGroup     = <%=$Security_Props{'MBY_PG1'}%>;
  Security_ReadAccess_Str  = <%=$Security_Props{'MBY_PG1_RAC_AGENTS'}%>;
  Security_WriteAccess_Str = <%=$Security_Props{'MBY_PG1_WAC_AGENTS'}%>;
  shared;
  HandCoded = true;
  name = "MAC Statistic Tx Underrun";
  desc = "Stat: frames which experienced a transmit FIFO underrun";
  regwidth = 64;
  accesswidth = 64;
  field {
    AccessType = "RO/V";
    desc = "Frames which experienced a transmit FIFO underrun.";
    ValRandomize = true;
  } COUNT[63:0] = 64'h0;
};


//------------------------------------------------------------------------------
// MAC_STAT_TX_DRAIN_DROP

reg mac_stat_tx_drain_drop_r {
  Security_PolicyGroup     = <%=$Security_Props{'MBY_PG1'}%>;
  Security_ReadAccess_Str  = <%=$Security_Props{'MBY_PG1_RAC_AGENTS'}%>;
  Security_WriteAccess_Str = <%=$Security_Props{'MBY_PG1_WAC_AGENTS'}%>;
  shared;
  HandCoded = true;
  name = "MAC Statistic Tx Drain Drop";
  desc = "Stat: frames truncated or dropped due to drain";
  regwidth = 64;
  accesswidth = 64;
  field {
    AccessType = "RO/V";
    desc = "Frames truncated or dropped due to drain";
    ValRandomize = true;
  } COUNT[63:0] = 64'h0;
};

//------------------------------------------------------------------------------
// MAC_STAT_TX_PAUSE_XON

reg mac_stat_tx_pause_xon_r {
  Security_PolicyGroup     = <%=$Security_Props{'MBY_PG1'}%>;
  Security_ReadAccess_Str  = <%=$Security_Props{'MBY_PG1_RAC_AGENTS'}%>;
  Security_WriteAccess_Str = <%=$Security_Props{'MBY_PG1_WAC_AGENTS'}%>;
  shared;
  HandCoded = true;
  name = "MAC Statistic Tx Pause XON Register";
  desc = "Stat: Tx Pause XON packets sent";
  regwidth = 64;
  accesswidth = 64;
  field {
    AccessType = "RO/V";
    desc = "Pause XON (Quanta = 0) packets sent";
    ValRandomize = true;
  } COUNT[63:0] = 64'h0;
};


//------------------------------------------------------------------------------
// MAC_STAT_TX_PAUSE_XOFF

reg mac_stat_tx_pause_xoff_r {
  Security_PolicyGroup     = <%=$Security_Props{'MBY_PG1'}%>;
  Security_ReadAccess_Str  = <%=$Security_Props{'MBY_PG1_RAC_AGENTS'}%>;
  Security_WriteAccess_Str = <%=$Security_Props{'MBY_PG1_WAC_AGENTS'}%>;
  shared;
  HandCoded = true;
  name = "MAC Statistic Tx Pause XOFF Register";
  desc = "Stat: Tx Pause XOFF packets sent";
  regwidth = 64;
  accesswidth = 64;
  field {
    AccessType = "RO/V";
    desc = "Pause XOFF (Quanta != 0) packets sent";
    ValRandomize = true;
  } COUNT[63:0] = 64'h0;
};

//------------------------------------------------------------------------------
// MAC_STAT_TX_PFC[0..7]

reg mac_stat_tx_pfc_r {
  Security_PolicyGroup     = <%=$Security_Props{'MBY_PG1'}%>;
  Security_ReadAccess_Str  = <%=$Security_Props{'MBY_PG1_RAC_AGENTS'}%>;
  Security_WriteAccess_Str = <%=$Security_Props{'MBY_PG1_WAC_AGENTS'}%>;
  shared;
  HandCoded = true;
  name = "MAC Statistic Tx PFC Register";
  desc = "Stat: Tx PFC packets sent, one per PFC priority";
  regwidth = 64;
  accesswidth = 64;
  field {
    AccessType = "RO/V";
    desc = "PFC packets sent for the corresponding piority";
    ValRandomize = true;
  } COUNT[63:0] = 64'h0;
};


//------------------------------------------------------------------------------
// MAC_STAT_RX_OCTET

reg mac_stat_rx_octet_r {
  Security_PolicyGroup     = <%=$Security_Props{'MBY_PG1'}%>;
  Security_ReadAccess_Str  = <%=$Security_Props{'MBY_PG1_RAC_AGENTS'}%>;
  Security_WriteAccess_Str = <%=$Security_Props{'MBY_PG1_WAC_AGENTS'}%>;
  shared;
  HandCoded = true;
  name = "MAC Statistic Rx Octets";
  desc = "Stat: octets received in all frames";
  regwidth = 64;
  accesswidth = 64;
  field {
    AccessType = "RO/V";
    desc = "Octets received in all frames.";
    ValRandomize = true;
  } COUNT[63:0] = 64'h0;
};


//------------------------------------------------------------------------------
// MAC_STAT_RX_BAD_OCTET

reg mac_stat_rx_bad_octet_r {
  Security_PolicyGroup     = <%=$Security_Props{'MBY_PG1'}%>;
  Security_ReadAccess_Str  = <%=$Security_Props{'MBY_PG1_RAC_AGENTS'}%>;
  Security_WriteAccess_Str = <%=$Security_Props{'MBY_PG1_WAC_AGENTS'}%>;
  shared;
  HandCoded = true;
  name = "MAC Statistic Rx Bad Octets";
  desc = "Stat: octets received in all bad frames";
  regwidth = 64;
  accesswidth = 64;
  field {
    AccessType = "RO/V";
    desc = "Octets received in all bad frames.";
    ValRandomize = true;
  } COUNT[63:0] = 64'h0;
};


//------------------------------------------------------------------------------
// MAC_STAT_RX_FRAME

reg mac_stat_rx_frame_r {
  Security_PolicyGroup     = <%=$Security_Props{'MBY_PG1'}%>;
  Security_ReadAccess_Str  = <%=$Security_Props{'MBY_PG1_RAC_AGENTS'}%>;
  Security_WriteAccess_Str = <%=$Security_Props{'MBY_PG1_WAC_AGENTS'}%>;
  shared;
  HandCoded = true;
  name = "MAC Statistic Rx Frames";
  desc = "Stat: frames received";
  regwidth = 64;
  accesswidth = 64;
  field {
    AccessType = "RO/V";
    desc = "Frames received.";
    ValRandomize = true;
  } COUNT[63:0] = 64'h0;
};


//------------------------------------------------------------------------------
// MAC_STAT_RX_BAD_FRAME

reg mac_stat_rx_bad_frame_r {
  Security_PolicyGroup     = <%=$Security_Props{'MBY_PG1'}%>;
  Security_ReadAccess_Str  = <%=$Security_Props{'MBY_PG1_RAC_AGENTS'}%>;
  Security_WriteAccess_Str = <%=$Security_Props{'MBY_PG1_WAC_AGENTS'}%>;
  shared;
  HandCoded = true;
  name = "MAC Statistic Rx Bad Frames";
  desc = "Stat: bad frames received";
  regwidth = 64;
  accesswidth = 64;
  field {
    AccessType = "RO/V";
    desc = "Bad frames received.";
    ValRandomize = true;
  } COUNT[63:0] = 64'h0;
};


//------------------------------------------------------------------------------
// MAC_STAT_RX_PAUSE_XON

reg mac_stat_rx_pause_xon_r {
  Security_PolicyGroup     = <%=$Security_Props{'MBY_PG1'}%>;
  Security_ReadAccess_Str  = <%=$Security_Props{'MBY_PG1_RAC_AGENTS'}%>;
  Security_WriteAccess_Str = <%=$Security_Props{'MBY_PG1_WAC_AGENTS'}%>;
  shared;
  HandCoded = true;
  name = "MAC Statistic Rx Pause XON";
  desc = "Stat: IEEE 802.3 pause XON frames received";
  regwidth = 64;
  accesswidth = 64;
  field {
    AccessType = "RO/V";
    desc = "IEEE 802.3 pause XON frames (quanta = 0) received.";
    ValRandomize = true;
  } COUNT[63:0] = 64'h0;
};

//------------------------------------------------------------------------------
// MAC_STAT_RX_PAUSE_XOFF

reg mac_stat_rx_pause_xoff_r {
  Security_PolicyGroup     = <%=$Security_Props{'MBY_PG1'}%>;
  Security_ReadAccess_Str  = <%=$Security_Props{'MBY_PG1_RAC_AGENTS'}%>;
  Security_WriteAccess_Str = <%=$Security_Props{'MBY_PG1_WAC_AGENTS'}%>;
  shared;
  HandCoded = true;
  name = "MAC Statistic Rx Pause XOFF";
  desc = "Stat: IEEE 802.3 pause XOFF frames received";
  regwidth = 64;
  accesswidth = 64;
  field {
    AccessType = "RO/V";
    desc = "IEEE 802.3 pause XOFF frames (quanta != 0) received.";
    ValRandomize = true;
  } COUNT[63:0] = 64'h0;
};


//------------------------------------------------------------------------------
// MAC_STAT_RX_PFC[0..7]

reg mac_stat_rx_pfc_r {
  Security_PolicyGroup     = <%=$Security_Props{'MBY_PG1'}%>;
  Security_ReadAccess_Str  = <%=$Security_Props{'MBY_PG1_RAC_AGENTS'}%>;
  Security_WriteAccess_Str = <%=$Security_Props{'MBY_PG1_WAC_AGENTS'}%>;
  shared;
  HandCoded = true;
  name = "MAC Statistic Rx PFC";
  desc = "Stat: IEEE 802.1 PFC frames received, one per priority";
  regwidth = 64;
  accesswidth = 64;
  field {
    AccessType = "RO/V";
    desc = "IEEE 802.1 PFC frames received for the corresponding priority";
    ValRandomize = true;
  } COUNT[63:0] = 64'h0;
};


//------------------------------------------------------------------------------
// MAC_STAT_RX_CONTROL

reg mac_stat_rx_control_r {
  Security_PolicyGroup     = <%=$Security_Props{'MBY_PG1'}%>;
  Security_ReadAccess_Str  = <%=$Security_Props{'MBY_PG1_RAC_AGENTS'}%>;
  Security_WriteAccess_Str = <%=$Security_Props{'MBY_PG1_WAC_AGENTS'}%>;
  shared;
  HandCoded = true;
  name = "MAC Statistic Rx Control Frames";
  desc = "Stat: control frames received other than pause or PFC";
  regwidth = 64;
  accesswidth = 64;
  field {
    AccessType = "RO/V";
    desc = "IEEE 802.3 control frames (other than pause or PFC) received";
    ValRandomize = true;
  } COUNT[63:0] = 64'h0;
};


//------------------------------------------------------------------------------
// MAC_STAT_RX_FCS_ERROR

reg mac_stat_rx_fcs_error_r {
  Security_PolicyGroup     = <%=$Security_Props{'MBY_PG1'}%>;
  Security_ReadAccess_Str  = <%=$Security_Props{'MBY_PG1_RAC_AGENTS'}%>;
  Security_WriteAccess_Str = <%=$Security_Props{'MBY_PG1_WAC_AGENTS'}%>;
  shared;
  HandCoded = true;
  name = "MAC Statistic Rx FCS Error";
  desc = "Stat: frames received with a bad CRC";
  regwidth = 64;
  accesswidth = 64;
  field {
    AccessType = "RO/V";
    desc = "frames received with a bad CRC";
    ValRandomize = true;
  } COUNT[63:0] = 64'h0;
};


//------------------------------------------------------------------------------
// MAC_STAT_RX_RUNT

reg mac_stat_rx_runt_r {
  Security_PolicyGroup     = <%=$Security_Props{'MBY_PG1'}%>;
  Security_ReadAccess_Str  = <%=$Security_Props{'MBY_PG1_RAC_AGENTS'}%>;
  Security_WriteAccess_Str = <%=$Security_Props{'MBY_PG1_WAC_AGENTS'}%>;
  shared;
  HandCoded = true;
  name = "MAC Statistic Rx Runt";
  desc = "Stat: frames received with length less than 64 and a bad CRC";
  regwidth = 64;
  accesswidth = 64;
  field {
    AccessType = "RO/V";
    desc = "Frames received with length less than 64 and a bad CRC.";
    ValRandomize = true;
  } COUNT[63:0] = 64'h0;
};


//------------------------------------------------------------------------------
// MAC_STAT_RX_UNDERSIZE

reg mac_stat_rx_undersize_r {
  Security_PolicyGroup     = <%=$Security_Props{'MBY_PG1'}%>;
  Security_ReadAccess_Str  = <%=$Security_Props{'MBY_PG1_RAC_AGENTS'}%>;
  Security_WriteAccess_Str = <%=$Security_Props{'MBY_PG1_WAC_AGENTS'}%>;
  shared;
  HandCoded = true;
  name = "MAC Statistic Rx Undersize";
  desc = "Stat: frames received with length less than 64 and a good CRC";
  regwidth = 64;
  accesswidth = 64;
  field {
    AccessType = "RO/V";
    desc = "Frames received with length less than 64 and a good CRC.";
    ValRandomize = true;
  } COUNT[63:0] = 64'h0;
};

//------------------------------------------------------------------------------
// MAC_STAT_RX_CODE_ERROR

reg mac_stat_rx_code_error_r {
  Security_PolicyGroup     = <%=$Security_Props{'MBY_PG1'}%>;
  Security_ReadAccess_Str  = <%=$Security_Props{'MBY_PG1_RAC_AGENTS'}%>;
  Security_WriteAccess_Str = <%=$Security_Props{'MBY_PG1_WAC_AGENTS'}%>;
  shared;
  HandCoded = true;
  name = "MAC Statistic Rx Undersize";
  desc = "Stat: frames received with length less than 64 and a good CRC";
  regwidth = 64;
  accesswidth = 64;
  field {
    AccessType = "RO/V";
    desc = "Frames received with length less than 64 and a good CRC.";
    ValRandomize = true;
  } COUNT[63:0] = 64'h0;
};


//------------------------------------------------------------------------------
// MAC_STAT_RX_UC

reg mac_stat_rx_uc_r {
  Security_PolicyGroup     = <%=$Security_Props{'MBY_PG1'}%>;
  Security_ReadAccess_Str  = <%=$Security_Props{'MBY_PG1_RAC_AGENTS'}%>;
  Security_WriteAccess_Str = <%=$Security_Props{'MBY_PG1_WAC_AGENTS'}%>;
  shared;
  HandCoded = true;
  name = "MAC Statistic Rx Unicast Frame";
  desc = "Stat: frames received as unicast frame";
  regwidth = 64;
  accesswidth = 64;
  field {
    AccessType = "RO/V";
    desc = "Frames received with unicast frame.";
    ValRandomize = true;
  } COUNT[63:0] = 64'h0;
};


//------------------------------------------------------------------------------
// MAC_STAT_RX_MC

reg mac_stat_rx_mc_r {
  Security_PolicyGroup     = <%=$Security_Props{'MBY_PG1'}%>;
  Security_ReadAccess_Str  = <%=$Security_Props{'MBY_PG1_RAC_AGENTS'}%>;
  Security_WriteAccess_Str = <%=$Security_Props{'MBY_PG1_WAC_AGENTS'}%>;
  shared;
  HandCoded = true;
  name = "MAC Statistic Rx Multicast Frame";
  desc = "Stat: frames received as multicast frame";
  regwidth = 64;
  accesswidth = 64;
  field {
    AccessType = "RO/V";
    desc = "Frames received with multicast frame.";
    ValRandomize = true;
  } COUNT[63:0] = 64'h0;
};

//------------------------------------------------------------------------------
// MAC_STAT_RX_BC

reg mac_stat_rx_bc_r {
  Security_PolicyGroup     = <%=$Security_Props{'MBY_PG1'}%>;
  Security_ReadAccess_Str  = <%=$Security_Props{'MBY_PG1_RAC_AGENTS'}%>;
  Security_WriteAccess_Str = <%=$Security_Props{'MBY_PG1_WAC_AGENTS'}%>;
  shared;
  HandCoded = true;
  name = "MAC Statistic Rx Broadcast Frame";
  desc = "Stat: frames received as broadcast frame";
  regwidth = 64;
  accesswidth = 64;
  field {
    AccessType = "RO/V";
    desc = "Frames received with broadcast frame.";
    ValRandomize = true;
  } COUNT[63:0] = 64'h0;
};


//------------------------------------------------------------------------------
// MAC_STAT_RX_64

reg mac_stat_rx_64_r {
  Security_PolicyGroup     = <%=$Security_Props{'MBY_PG1'}%>;
  Security_ReadAccess_Str  = <%=$Security_Props{'MBY_PG1_RAC_AGENTS'}%>;
  Security_WriteAccess_Str = <%=$Security_Props{'MBY_PG1_WAC_AGENTS'}%>;
  shared;
  HandCoded = true;
  name = "MAC Statistic Rx Length 64";
  desc = "Stat: frames received with length == 64";
  regwidth = 64;
  accesswidth = 64;
  field {
    AccessType = "RO/V";
    desc = "Frames received with length == 64.";
    ValRandomize = true;
  } COUNT[63:0] = 64'h0;
};


//------------------------------------------------------------------------------
// MAC_STAT_RX_65

reg mac_stat_rx_65_r {
  Security_PolicyGroup     = <%=$Security_Props{'MBY_PG1'}%>;
  Security_ReadAccess_Str  = <%=$Security_Props{'MBY_PG1_RAC_AGENTS'}%>;
  Security_WriteAccess_Str = <%=$Security_Props{'MBY_PG1_WAC_AGENTS'}%>;
  shared;
  HandCoded = true;
  name = "MAC Statistic Rx Length 65";
  desc = "Stat: frames received with length from 65 through 127";
  regwidth = 64;
  accesswidth = 64;
  field {
    AccessType = "RO/V";
    desc = "Frames received with length from 65 through 127.";
    ValRandomize = true;
  } COUNT[63:0] = 64'h0;
};


//------------------------------------------------------------------------------
// MAC_STAT_RX_128

reg mac_stat_rx_128_r {
  Security_PolicyGroup     = <%=$Security_Props{'MBY_PG1'}%>;
  Security_ReadAccess_Str  = <%=$Security_Props{'MBY_PG1_RAC_AGENTS'}%>;
  Security_WriteAccess_Str = <%=$Security_Props{'MBY_PG1_WAC_AGENTS'}%>;
  shared;
  HandCoded = true;
  name = "MAC Statistic Rx Length 128";
  desc = "Stat: frames received with length from 128 through 255";
  regwidth = 64;
  accesswidth = 64;
  field {
    AccessType = "RO/V";
    desc = "Frames received with length from 128 through 255.";
    ValRandomize = true;
  } COUNT[63:0] = 64'h0;
};


//------------------------------------------------------------------------------
// MAC_STAT_RX_256

reg mac_stat_rx_256_r {
  Security_PolicyGroup     = <%=$Security_Props{'MBY_PG1'}%>;
  Security_ReadAccess_Str  = <%=$Security_Props{'MBY_PG1_RAC_AGENTS'}%>;
  Security_WriteAccess_Str = <%=$Security_Props{'MBY_PG1_WAC_AGENTS'}%>;
  shared;
  HandCoded = true;
  name = "MAC Statistic Rx Length 256";
  desc = "Stat: frames received with length from 256 through 511";
  regwidth = 64;
  accesswidth = 64;
  field {
    AccessType = "RO/V";
    desc = "Frames received with length from 256 through 511.";
    ValRandomize = true;
  } COUNT[63:0] = 64'h0;
};


//------------------------------------------------------------------------------
// MAC_STAT_RX_512

reg mac_stat_rx_512_r {
  Security_PolicyGroup     = <%=$Security_Props{'MBY_PG1'}%>;
  Security_ReadAccess_Str  = <%=$Security_Props{'MBY_PG1_RAC_AGENTS'}%>;
  Security_WriteAccess_Str = <%=$Security_Props{'MBY_PG1_WAC_AGENTS'}%>;
  shared;
  HandCoded = true;
  name = "MAC Statistic Rx Length 512";
  desc = "Stat: frames received with length from 512 through 1023";
  regwidth = 64;
  accesswidth = 64;
  field {
    AccessType = "RO/V";
    desc = "Frames received with length from 512 through 1023.";
    ValRandomize = true;
  } COUNT[63:0] = 64'h0;
};


//------------------------------------------------------------------------------
// MAC_STAT_RX_1024

reg mac_stat_rx_1024_r {
  Security_PolicyGroup     = <%=$Security_Props{'MBY_PG1'}%>;
  Security_ReadAccess_Str  = <%=$Security_Props{'MBY_PG1_RAC_AGENTS'}%>;
  Security_WriteAccess_Str = <%=$Security_Props{'MBY_PG1_WAC_AGENTS'}%>;
  shared;
  HandCoded = true;
  name = "MAC Statistic Rx Length 1024";
  desc = "Stat: frames received with length from 1024 through 1518";
  regwidth = 64;
  accesswidth = 64;
  field {
    AccessType = "RO/V";
    desc = "Frames received with length from 1024 through 1519.";
    ValRandomize = true;
  } COUNT[63:0] = 64'h0;
};


//------------------------------------------------------------------------------
// MAC_STAT_RX_1519

reg mac_stat_rx_1519_r {
  Security_PolicyGroup     = <%=$Security_Props{'MBY_PG1'}%>;
  Security_ReadAccess_Str  = <%=$Security_Props{'MBY_PG1_RAC_AGENTS'}%>;
  Security_WriteAccess_Str = <%=$Security_Props{'MBY_PG1_WAC_AGENTS'}%>;
  shared;
  HandCoded = true;
  name = "MAC Statistic Rx Length 1519";
  desc = "Stat: frames received with length from 1519 through max_length";
  regwidth = 64;
  accesswidth = 64;
  field {
    AccessType = "RO/V";
    desc = "Frames received with length from 1519 through max_length.";
    ValRandomize = true;
  } COUNT[63:0] = 64'h0;
};


//------------------------------------------------------------------------------
// MAC_STAT_RX_OVERSIZE

reg mac_stat_rx_oversize_r {
  Security_PolicyGroup     = <%=$Security_Props{'MBY_PG1'}%>;
  Security_ReadAccess_Str  = <%=$Security_Props{'MBY_PG1_RAC_AGENTS'}%>;
  Security_WriteAccess_Str = <%=$Security_Props{'MBY_PG1_WAC_AGENTS'}%>;
  shared;
  HandCoded = true;
  name = "MAC Statistic Rx Oversize";
  desc = "Stat: frames received with length > max_length and a good CRC";
  regwidth = 64;
  accesswidth = 64;
  field {
    AccessType = "RO/V";
    desc = "Frames received with length > max_length and a good CRC.";
    ValRandomize = true;
  } COUNT[63:0] = 64'h0;
};


//------------------------------------------------------------------------------
// MAC_STAT_RX_JABBER

reg mac_stat_rx_jabber_r {
  Security_PolicyGroup     = <%=$Security_Props{'MBY_PG1'}%>;
  Security_ReadAccess_Str  = <%=$Security_Props{'MBY_PG1_RAC_AGENTS'}%>;
  Security_WriteAccess_Str = <%=$Security_Props{'MBY_PG1_WAC_AGENTS'}%>;
  shared;
  HandCoded = true;
  name = "MAC Statistic Rx Jabber";
  desc = "Stat: frames received with length > max_length and a bad CRC";
  regwidth = 64;
  accesswidth = 64;
  field {
    AccessType = "RO/V";
    desc = "Frames received with length > max_length and a bad CRC.";
    ValRandomize = true;
  } COUNT[63:0] = 64'h0;
};


//------------------------------------------------------------------------------
// MAC_STAT_RX_OVERRUN

reg mac_stat_rx_overrun_r {
  Security_PolicyGroup     = <%=$Security_Props{'MBY_PG1'}%>;
  Security_ReadAccess_Str  = <%=$Security_Props{'MBY_PG1_RAC_AGENTS'}%>;
  Security_WriteAccess_Str = <%=$Security_Props{'MBY_PG1_WAC_AGENTS'}%>;
  shared;
  HandCoded = true;
  name = "MAC Statistic Rx Overrun";
  desc = "Stat: frames which experienced a receive FIFO overrun";
  regwidth = 64;
  accesswidth = 64;
  field {
    AccessType = "RO/V";
    desc = "Frames which experienced a receive FIFO overrun.";
    ValRandomize = true;
  } COUNT[63:0] = 64'h0;
};


//------------------------------------------------------------------------------
// MAC_STAT_RX_DRAIN_DROP

reg mac_stat_rx_drain_drop_r {
  Security_PolicyGroup     = <%=$Security_Props{'MBY_PG1'}%>;
  Security_ReadAccess_Str  = <%=$Security_Props{'MBY_PG1_RAC_AGENTS'}%>;
  Security_WriteAccess_Str = <%=$Security_Props{'MBY_PG1_WAC_AGENTS'}%>;
  shared;
  HandCoded = true;
  name = "MAC Statistic Rx Drain Drop";
  desc = "Stat: frames truncated or dropped due to drain";
  regwidth = 64;
  accesswidth = 64;
  field {
    AccessType = "RO/V";
    desc = "Frames truncated or dropped due to drain.";
    ValRandomize = true;
  } COUNT[63:0] = 64'h0;
};


//------------------------------------------------------------------------------
// MAC_STAT_RX_MSDATA_DROP

reg mac_stat_rx_msdata_drop_r {
  Security_PolicyGroup     = <%=$Security_Props{'MBY_PG1'}%>;
  Security_ReadAccess_Str  = <%=$Security_Props{'MBY_PG1_RAC_AGENTS'}%>;
  Security_WriteAccess_Str = <%=$Security_Props{'MBY_PG1_WAC_AGENTS'}%>;
  shared;
  HandCoded = true;
  name = "MAC Statistic Rx Msdata Drop";
  desc = "Stat: frames dropped due to missing msdata";
  regwidth = 64;
  accesswidth = 64;
  field {
    AccessType = "RO/V";
    desc = "Frames dropped due to missing msdata.";
    ValRandomize = true;
  } COUNT[63:0] = 64'h0;
};

//------------------------------------------------------------------------------
// MAC_STAT_LINK_NO_FAULT

reg mac_stat_link_no_fault_r {
  Security_PolicyGroup     = <%=$Security_Props{'MBY_PG1'}%>;
  Security_ReadAccess_Str  = <%=$Security_Props{'MBY_PG1_RAC_AGENTS'}%>;
  Security_WriteAccess_Str = <%=$Security_Props{'MBY_PG1_WAC_AGENTS'}%>;
  shared;
  HandCoded = true;
  name = "MAC Statistic Transition from Local or Remote Fault to No Fault";
  desc = "Stat: Count transition from Local or Remote fault to No Fault";
  regwidth = 64;
  accesswidth = 64;
  field {
    AccessType = "RO/V";
    desc = "Count transition from Local or Remote fault to No Fault.";
    ValRandomize = true;
  } COUNT[63:0] = 64'h0;
};

//------------------------------------------------------------------------------
// MAC_STAT_LINK_LOCAL_FAULT

reg mac_stat_link_local_fault_r {
  Security_PolicyGroup     = <%=$Security_Props{'MBY_PG1'}%>;
  Security_ReadAccess_Str  = <%=$Security_Props{'MBY_PG1_RAC_AGENTS'}%>;
  Security_WriteAccess_Str = <%=$Security_Props{'MBY_PG1_WAC_AGENTS'}%>;
  shared;
  HandCoded = true;
  name = "MAC Statistic Transition from No Fault to Local Fault";
  desc = "Stat: Count transition from No Fault to Local Fault";
  regwidth = 64;
  accesswidth = 64;
  field {
    AccessType = "RO/V";
    desc = "Count transition from No Fault to Local Fault.";
    ValRandomize = true;
  } COUNT[63:0] = 64'h0;
};

//------------------------------------------------------------------------------
// MAC_STAT_LINK_REMOTE_FAULT

reg mac_stat_link_remote_fault_r {
  Security_PolicyGroup     = <%=$Security_Props{'MBY_PG1'}%>;
  Security_ReadAccess_Str  = <%=$Security_Props{'MBY_PG1_RAC_AGENTS'}%>;
  Security_WriteAccess_Str = <%=$Security_Props{'MBY_PG1_WAC_AGENTS'}%>;
  shared;
  HandCoded = true;
  name = "MAC Statistic Transition from No Fault to Remote Fault";
  desc = "Stat: Count transition from No Fault to Remote Fault";
  regwidth = 64;
  accesswidth = 64;
  field {
    AccessType = "RO/V";
    desc = "Count transition from No Fault to Remote Fault.";
    ValRandomize = true;
  } COUNT[63:0] = 64'h0;
};


//------------------------------------------------------------------------------
// addrmap section

addrmap epl_mac_map_regs {
  name = "epl_mac";
  desc = "MAC Registers";
  addressing = fullalign;
  Space = "MSG";
  Opcode = "MEM-SB";
  No_IOSF_Primary=true;

  mac_ip_r                       MAC_IP 		       ;
  mac_im_r                       MAC_IM 		       ;
  mac_scratch_r                  MAC_SCRATCH 		       ;
  
  mac_da_address_r               MAC_DA_ADDRESS[5]	       ;
  mac_magic_pkt_filter_cfg_r     MAC_MAGIC_PKT_FILTER_CFG      ;
  mac_cfg_r                      MAC_CFG		       ;
  mac_path_cfg_r                 MAC_PATH_CFG		       ;
  mac_status_r                   MAC_STATUS		       ;
  mac_sa_r                       MAC_SA 		       ;

  mac_tx_mii_cfg_r               MAC_TX_MII_CFG 	       ;
  mac_tx_path_cfg_r              MAC_TX_PATH_CFG	       ;
  mac_tx_sequence_r              MAC_TX_SEQUENCE	       ;
  mac_tx_control_status_r        MAC_TX_CONTROL_STATUS         ;
  
  mac_rx_mii_cfg_r               MAC_RX_MII_CFG 	       ;
  mac_rx_path_cfg_r              MAC_RX_PATH_CFG	       ;
  mac_rx_parser_cfg_1_r          MAC_RX_PARSER_CFG_1	       ;
  mac_rx_parser_cfg_2_r          MAC_RX_PARSER_CFG_2	       ;
  mac_rx_parser_vlan_tc_r        MAC_RX_PARSER_VLAN_TC	       ;
  mac_rx_parser_mpls_tc_r        MAC_RX_PARSER_MPLS_TC	       ;
  mac_rx_parser_dscp_tc_r        MAC_RX_PARSER_DSCP_TC[64]     ;
  mac_rx_parser_default_tc_r     MAC_RX_PARSER_DEFAULT_TC      ;
  mac_rx_sequence_r              MAC_RX_SEQUENCE	       ;
  mac_rx_control_status_r        MAC_RX_CONTROL_STATUS         ;
  mac_rx_link_counter_r          MAC_RX_LINK_COUNTER	       ;
  mac_rx_parser_counter_r        MAC_RX_PARSER_COUNTER         ;
  
  mac_pia_cfg_r                  MAC_PIA_CFG		       ;
  mac_pia_status_r               MAC_PIA_STATUS 	       ;
  mac_xoff_time_threshold_r      MAC_XOFF_TIME_THRESHOLD       ;
  mac_pause_time_base_r          MAC_PAUSE_TIME_BASE           ;
  
  mac_stat_tx_octet_r            MAC_STAT_TX_OCTET	       ;
  mac_stat_tx_bad_octet_r        MAC_STAT_TX_BAD_OCTET         ;
  mac_stat_tx_frame_r            MAC_STAT_TX_FRAME	       ;
  mac_stat_tx_bad_frame_r        MAC_STAT_TX_BAD_FRAME         ;
  mac_stat_tx_control_r          MAC_STAT_TX_CONTROL	       ;
  mac_stat_tx_fcs_error_r        MAC_STAT_TX_FCS_ERROR         ;
  mac_stat_tx_uc_r               MAC_STAT_TX_UC 	       ;
  mac_stat_tx_mc_r               MAC_STAT_TX_MC 	       ;
  mac_stat_tx_bc_r               MAC_STAT_TX_BC 	       ;
  mac_stat_tx_64_r               MAC_STAT_TX_64 	       ;
  mac_stat_tx_65_r               MAC_STAT_TX_65 	       ;
  mac_stat_tx_128_r              MAC_STAT_TX_128	       ;
  mac_stat_tx_256_r              MAC_STAT_TX_256	       ;
  mac_stat_tx_512_r              MAC_STAT_TX_512	       ;
  mac_stat_tx_1024_r             MAC_STAT_TX_1024	       ;
  mac_stat_tx_1519_r             MAC_STAT_TX_1519	       ;
  mac_stat_tx_oversize_r         MAC_STAT_TX_OVERSIZE	       ;
  mac_stat_tx_jabber_r           MAC_STAT_TX_JABBER	       ;
  mac_stat_tx_underrun_r         MAC_STAT_TX_UNDERRUN	       ;
  mac_stat_tx_drain_drop_r       MAC_STAT_TX_DRAIN_DROP        ;
  mac_stat_tx_pause_xon_r        MAC_STAT_TX_PAUSE_XON	       ;
  mac_stat_tx_pause_xoff_r       MAC_STAT_TX_PAUSE_XOFF	       ;
  mac_stat_tx_pfc_r              MAC_STAT_TX_PFC[8]	       ;
  
  mac_stat_rx_octet_r            MAC_STAT_RX_OCTET	       ;
  mac_stat_rx_bad_octet_r        MAC_STAT_RX_BAD_OCTET         ;
  mac_stat_rx_frame_r            MAC_STAT_RX_FRAME	       ;
  mac_stat_rx_bad_frame_r        MAC_STAT_RX_BAD_FRAME         ;
  mac_stat_rx_pause_xon_r        MAC_STAT_RX_PAUSE_XON	       ;
  mac_stat_rx_pause_xoff_r       MAC_STAT_RX_PAUSE_XOFF	       ;
  mac_stat_rx_pfc_r              MAC_STAT_RX_PFC[8]	       ;
  mac_stat_rx_control_r          MAC_STAT_RX_CONTROL	       ;
  mac_stat_rx_fcs_error_r        MAC_STAT_RX_FCS_ERROR         ;
  mac_stat_rx_runt_r             MAC_STAT_RX_RUNT	       ;
  mac_stat_rx_undersize_r        MAC_STAT_RX_UNDERSIZE         ;
  mac_stat_rx_code_error_r       MAC_STAT_RX_CODE_ERROR        ;
  mac_stat_rx_uc_r               MAC_STAT_RX_UC 	       ;
  mac_stat_rx_mc_r               MAC_STAT_RX_MC 	       ;
  mac_stat_rx_bc_r               MAC_STAT_RX_BC 	       ;
  mac_stat_rx_64_r               MAC_STAT_RX_64 	       ;
  mac_stat_rx_65_r               MAC_STAT_RX_65 	       ;
  mac_stat_rx_128_r              MAC_STAT_RX_128	       ;
  mac_stat_rx_256_r              MAC_STAT_RX_256	       ;
  mac_stat_rx_512_r              MAC_STAT_RX_512	       ;
  mac_stat_rx_1024_r             MAC_STAT_RX_1024	       ;
  mac_stat_rx_1519_r             MAC_STAT_RX_1519	       ;
  mac_stat_rx_oversize_r         MAC_STAT_RX_OVERSIZE	       ;
  mac_stat_rx_jabber_r           MAC_STAT_RX_JABBER	       ;
  mac_stat_rx_overrun_r          MAC_STAT_RX_OVERRUN	       ;
  mac_stat_rx_drain_drop_r       MAC_STAT_RX_DRAIN_DROP        ;
  mac_stat_rx_msdata_drop_r      MAC_STAT_RX_MSDATA_DROP       ;
  mac_stat_link_no_fault_r       MAC_STAT_LINK_NO_FAULT        ;
  mac_stat_link_local_fault_r    MAC_STAT_LINK_LOCAL_FAULT     ;
  mac_stat_link_remote_fault_r   MAC_STAT_LINK_REMOTE_FAULT    ;
};


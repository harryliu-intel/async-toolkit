(defun busnew ()
             (let (view shapes)
                    view = (geGetEditCellView)
	fl = infile("/home/user/vjain/alpine/bus.list")
	;gets(k fl)
	while(gets(k fl) != nil
	text1 = parseString(k "\n")
	txt=car(text1)
	;point1=car(evalstring(car(text1)))
	(when (txt!="OBS")
	point1=car(evalstring(car(text1)))
	;text = parseString(k "\n")
	;point=evalstring(car(text))
	gets(k fl)
	text = parseString(k "\n")
	point=evalstring(car(text))
	;text1 = parseString(k "\n")
	;point1=car(evalstring(car(text1)))
        x=dbCreatePath(view (list point1 "bus") point 0.06)
	;(dbReplaceProp x "BusPattern" "boolean" t)
	gets(k fl)
	;s=car((wcv()->shapes))
	;(dbReplaceProp s "BusPattern" "boolean" t)
	gets(k fl)
	text2 = parseString(k " \n")
	point2=car(text2)
	;(dbReplaceProp x "BusPattern" "string" point2)
	gets(k fl)
	text3 = parseString(k " \n")
	point3=car(text3)
	(dbReplaceProp x "BusPattern" "string" point2)
	(when (k==" \n")
	(dbReplaceProp x "BusPrefix" "string" " "))
	(when (k!=" \n")
	(dbReplaceProp x "BusPrefix" "string" point3))
	gets(k fl)
	text4 = parseString(k " \n")
	point4=car(text4)
	(dbReplaceProp x "BusPin" "boolean" point4)
	gets(k fl)
	text5 = parseString(k " \n")
	point5=car(text5)
	(dbReplaceProp x "BusFlipX" "boolean" point5)
	gets(k fl)
	text6 = parseString(k " \n")
	point6=car(text6)
	(dbReplaceProp x "BusFlipY" "boolean" point6)
	gets(k fl)
	text7 = parseString(k " \n")
	point7=car(text7)
	(dbReplaceProp x "BusStartVias" "boolean" point7)
	gets(k fl)
	text8 = parseString(k " \n")
	point8=car(text8)
	(dbReplaceProp x "BusEndVias" "boolean" point8)
	gets(k fl)
	text9 = parseString(k " \n")
	point9=evalstring(car(text9))
	(dbReplaceProp x "BusArrayPitch" "float" point9)
	gets(k fl)
	text10 = parseString(k " \n")
	point10=car(text10)
	(dbReplaceProp x "BusDoubleVias" "boolean" point10)
	gets(k fl)
	gets(k fl)
	)
	(when (txt=="OBS")
	gets(k fl)
	text11 = parseString(k "\n")
	point11=evalstring(car(text11))
	(when (k!="list()\n")
	x=dbCreatePolygon(view (list "OBS" "bus") point11)
	gets(k fl)
	gets(k fl)
	text1 = parseString(k " \n")
	point1=car(text1)
	(dbReplaceProp x "M2" "boolean" point1)
	gets(k fl)
	text2 = parseString(k " \n")
	point2=car(text2)
	(dbReplaceProp x "M3" "boolean" point2)
	gets(k fl)
	text3 = parseString(k " \n")
	point3=car(text3)
	(dbReplaceProp x "M4" "boolean" point3)
	gets(k fl)
	text4 = parseString(k " \n")
	point4=car(text4)
	(dbReplaceProp x "M5" "boolean" point4)
	gets(k fl)
	text5 = parseString(k " \n")
	point5=car(text5)
	(dbReplaceProp x "M6" "boolean" point5)
	gets(k fl)
	text6 = parseString(k " \n")
	point6=car(text6)
	(dbReplaceProp x "M7" "boolean" point6)
	gets(k fl)
	text7 = parseString(k " \n")
	point7=car(text7)
	(dbReplaceProp x "M1" "boolean" point7)
	gets(k fl)
	gets(k fl)
	gets(k fl)
	gets(k fl)

	)
	(when (k=="list()\n")
	gets(k fl)
	text12 = parseString(k "\n")
	point12=evalstring(car(text12))
	x=dbCreateRect(view (list "OBS" "bus") point12)
	gets(k fl)
	text1 = parseString(k " \n")
	point1=car(text1)
	(dbReplaceProp x "M2" "boolean" point1)
	gets(k fl)
	text2 = parseString(k " \n")
	point2=car(text2)
	(dbReplaceProp x "M3" "boolean" point2)
	gets(k fl)
	text3 = parseString(k " \n")
	point3=car(text3)
	(dbReplaceProp x "M4" "boolean" point3)
	gets(k fl)
	text4 = parseString(k " \n")
	point4=car(text4)
	(dbReplaceProp x "M5" "boolean" point4)
	gets(k fl)
	text5 = parseString(k " \n")
	point5=car(text5)
	(dbReplaceProp x "M6" "boolean" point5)
	gets(k fl)
	text6 = parseString(k " \n")
	point6=car(text6)
	(dbReplaceProp x "M7" "boolean" point6)
	gets(k fl)
	text7 = parseString(k " \n")
	point7=car(text7)
	(dbReplaceProp x "M1" "boolean" point7)
	gets(k fl)
	gets(k fl)
	gets(k fl)
	gets(k fl)

	)
		)
)))
;)
;close(out)
;))
